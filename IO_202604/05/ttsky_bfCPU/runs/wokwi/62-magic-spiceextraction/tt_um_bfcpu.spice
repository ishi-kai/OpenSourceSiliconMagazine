* NGSPICE file created from tt_um_bfcpu.ext - technology: sky130A

* Black-box entry subcircuit for sky130_fd_sc_hd__fill_1 abstract view
.subckt sky130_fd_sc_hd__fill_1 VGND VNB VPB VPWR
.ends

* Black-box entry subcircuit for sky130_ef_sc_hd__decap_12 abstract view
.subckt sky130_ef_sc_hd__decap_12 VPWR VGND VPB VNB
.ends

* Black-box entry subcircuit for sky130_fd_sc_hd__a21o_1 abstract view
.subckt sky130_fd_sc_hd__a21o_1 A1 A2 B1 VGND VNB VPB VPWR X
.ends

* Black-box entry subcircuit for sky130_fd_sc_hd__tapvpwrvgnd_1 abstract view
.subckt sky130_fd_sc_hd__tapvpwrvgnd_1 VGND VPWR
.ends

* Black-box entry subcircuit for sky130_fd_sc_hd__or4_1 abstract view
.subckt sky130_fd_sc_hd__or4_1 A B C D VGND VNB VPB VPWR X
.ends

* Black-box entry subcircuit for sky130_fd_sc_hd__diode_2 abstract view
.subckt sky130_fd_sc_hd__diode_2 DIODE VGND VNB VPB VPWR
.ends

* Black-box entry subcircuit for sky130_fd_sc_hd__mux2_1 abstract view
.subckt sky130_fd_sc_hd__mux2_1 A0 A1 S VGND VNB VPB VPWR X
.ends

* Black-box entry subcircuit for sky130_fd_sc_hd__dfrtp_4 abstract view
.subckt sky130_fd_sc_hd__dfrtp_4 CLK D RESET_B VGND VNB VPB VPWR Q
.ends

* Black-box entry subcircuit for sky130_fd_sc_hd__or2_1 abstract view
.subckt sky130_fd_sc_hd__or2_1 A B VGND VNB VPB VPWR X
.ends

* Black-box entry subcircuit for sky130_fd_sc_hd__dfxtp_1 abstract view
.subckt sky130_fd_sc_hd__dfxtp_1 CLK D VGND VNB VPB VPWR Q
.ends

* Black-box entry subcircuit for sky130_fd_sc_hd__o21a_1 abstract view
.subckt sky130_fd_sc_hd__o21a_1 A1 A2 B1 VGND VNB VPB VPWR X
.ends

* Black-box entry subcircuit for sky130_fd_sc_hd__dfrtp_1 abstract view
.subckt sky130_fd_sc_hd__dfrtp_1 CLK D RESET_B VGND VNB VPB VPWR Q
.ends

* Black-box entry subcircuit for sky130_fd_sc_hd__dlygate4sd3_1 abstract view
.subckt sky130_fd_sc_hd__dlygate4sd3_1 A VGND VNB VPB VPWR X
.ends

* Black-box entry subcircuit for sky130_fd_sc_hd__decap_4 abstract view
.subckt sky130_fd_sc_hd__decap_4 VGND VNB VPB VPWR
.ends

* Black-box entry subcircuit for sky130_fd_sc_hd__nor2_1 abstract view
.subckt sky130_fd_sc_hd__nor2_1 A B VGND VNB VPB VPWR Y
.ends

* Black-box entry subcircuit for sky130_fd_sc_hd__inv_2 abstract view
.subckt sky130_fd_sc_hd__inv_2 A VGND VNB VPB VPWR Y
.ends

* Black-box entry subcircuit for sky130_fd_sc_hd__clkbuf_4 abstract view
.subckt sky130_fd_sc_hd__clkbuf_4 A VGND VNB VPB VPWR X
.ends

* Black-box entry subcircuit for sky130_fd_sc_hd__buf_2 abstract view
.subckt sky130_fd_sc_hd__buf_2 A VGND VNB VPB VPWR X
.ends

* Black-box entry subcircuit for sky130_fd_sc_hd__nor3_2 abstract view
.subckt sky130_fd_sc_hd__nor3_2 A B C VGND VNB VPB VPWR Y
.ends

* Black-box entry subcircuit for sky130_fd_sc_hd__a22o_1 abstract view
.subckt sky130_fd_sc_hd__a22o_1 A1 A2 B1 B2 VGND VNB VPB VPWR X
.ends

* Black-box entry subcircuit for sky130_fd_sc_hd__decap_8 abstract view
.subckt sky130_fd_sc_hd__decap_8 VGND VNB VPB VPWR
.ends

* Black-box entry subcircuit for sky130_fd_sc_hd__nand2_1 abstract view
.subckt sky130_fd_sc_hd__nand2_1 A B VGND VNB VPB VPWR Y
.ends

* Black-box entry subcircuit for sky130_fd_sc_hd__xor2_1 abstract view
.subckt sky130_fd_sc_hd__xor2_1 A B VGND VNB VPB VPWR X
.ends

* Black-box entry subcircuit for sky130_fd_sc_hd__decap_6 abstract view
.subckt sky130_fd_sc_hd__decap_6 VGND VNB VPB VPWR
.ends

* Black-box entry subcircuit for sky130_fd_sc_hd__a31o_1 abstract view
.subckt sky130_fd_sc_hd__a31o_1 A1 A2 A3 B1 VGND VNB VPB VPWR X
.ends

* Black-box entry subcircuit for sky130_fd_sc_hd__a211o_1 abstract view
.subckt sky130_fd_sc_hd__a211o_1 A1 A2 B1 C1 VGND VNB VPB VPWR X
.ends

* Black-box entry subcircuit for sky130_fd_sc_hd__a21oi_1 abstract view
.subckt sky130_fd_sc_hd__a21oi_1 A1 A2 B1 VGND VNB VPB VPWR Y
.ends

* Black-box entry subcircuit for sky130_fd_sc_hd__and2_1 abstract view
.subckt sky130_fd_sc_hd__and2_1 A B VGND VNB VPB VPWR X
.ends

* Black-box entry subcircuit for sky130_fd_sc_hd__decap_3 abstract view
.subckt sky130_fd_sc_hd__decap_3 VGND VNB VPB VPWR
.ends

* Black-box entry subcircuit for sky130_fd_sc_hd__o211a_1 abstract view
.subckt sky130_fd_sc_hd__o211a_1 A1 A2 B1 C1 VGND VNB VPB VPWR X
.ends

* Black-box entry subcircuit for sky130_fd_sc_hd__fill_2 abstract view
.subckt sky130_fd_sc_hd__fill_2 VGND VNB VPB VPWR
.ends

* Black-box entry subcircuit for sky130_fd_sc_hd__nand2_2 abstract view
.subckt sky130_fd_sc_hd__nand2_2 A B VGND VNB VPB VPWR Y
.ends

* Black-box entry subcircuit for sky130_fd_sc_hd__and3_1 abstract view
.subckt sky130_fd_sc_hd__and3_1 A B C VGND VNB VPB VPWR X
.ends

* Black-box entry subcircuit for sky130_fd_sc_hd__or3_1 abstract view
.subckt sky130_fd_sc_hd__or3_1 A B C VGND VNB VPB VPWR X
.ends

* Black-box entry subcircuit for sky130_fd_sc_hd__or3b_1 abstract view
.subckt sky130_fd_sc_hd__or3b_1 A B C_N VGND VNB VPB VPWR X
.ends

* Black-box entry subcircuit for sky130_fd_sc_hd__o22a_1 abstract view
.subckt sky130_fd_sc_hd__o22a_1 A1 A2 B1 B2 VGND VNB VPB VPWR X
.ends

* Black-box entry subcircuit for sky130_fd_sc_hd__o21ai_2 abstract view
.subckt sky130_fd_sc_hd__o21ai_2 A1 A2 B1 VGND VNB VPB VPWR Y
.ends

* Black-box entry subcircuit for sky130_fd_sc_hd__clkbuf_2 abstract view
.subckt sky130_fd_sc_hd__clkbuf_2 A VGND VNB VPB VPWR X
.ends

* Black-box entry subcircuit for sky130_fd_sc_hd__a221o_1 abstract view
.subckt sky130_fd_sc_hd__a221o_1 A1 A2 B1 B2 C1 VGND VNB VPB VPWR X
.ends

* Black-box entry subcircuit for sky130_fd_sc_hd__a21bo_1 abstract view
.subckt sky130_fd_sc_hd__a21bo_1 A1 A2 B1_N VGND VNB VPB VPWR X
.ends

* Black-box entry subcircuit for sky130_fd_sc_hd__and2_2 abstract view
.subckt sky130_fd_sc_hd__and2_2 A B VGND VNB VPB VPWR X
.ends

* Black-box entry subcircuit for sky130_fd_sc_hd__a2bb2o_1 abstract view
.subckt sky130_fd_sc_hd__a2bb2o_1 A1_N A2_N B1 B2 VGND VNB VPB VPWR X
.ends

* Black-box entry subcircuit for sky130_fd_sc_hd__xnor2_1 abstract view
.subckt sky130_fd_sc_hd__xnor2_1 A B VGND VNB VPB VPWR Y
.ends

* Black-box entry subcircuit for sky130_fd_sc_hd__o311a_1 abstract view
.subckt sky130_fd_sc_hd__o311a_1 A1 A2 A3 B1 C1 VGND VNB VPB VPWR X
.ends

* Black-box entry subcircuit for sky130_fd_sc_hd__or3_4 abstract view
.subckt sky130_fd_sc_hd__or3_4 A B C VGND VNB VPB VPWR X
.ends

* Black-box entry subcircuit for sky130_fd_sc_hd__a221oi_2 abstract view
.subckt sky130_fd_sc_hd__a221oi_2 A1 A2 B1 B2 C1 VGND VNB VPB VPWR Y
.ends

* Black-box entry subcircuit for sky130_fd_sc_hd__nor3b_2 abstract view
.subckt sky130_fd_sc_hd__nor3b_2 A B C_N VGND VNB VPB VPWR Y
.ends

* Black-box entry subcircuit for sky130_fd_sc_hd__a2111o_1 abstract view
.subckt sky130_fd_sc_hd__a2111o_1 A1 A2 B1 C1 D1 VGND VNB VPB VPWR X
.ends

* Black-box entry subcircuit for sky130_fd_sc_hd__and2b_2 abstract view
.subckt sky130_fd_sc_hd__and2b_2 A_N B VGND VNB VPB VPWR X
.ends

* Black-box entry subcircuit for sky130_fd_sc_hd__or2_2 abstract view
.subckt sky130_fd_sc_hd__or2_2 A B VGND VNB VPB VPWR X
.ends

* Black-box entry subcircuit for sky130_fd_sc_hd__a41o_1 abstract view
.subckt sky130_fd_sc_hd__a41o_1 A1 A2 A3 A4 B1 VGND VNB VPB VPWR X
.ends

* Black-box entry subcircuit for sky130_fd_sc_hd__and3b_2 abstract view
.subckt sky130_fd_sc_hd__and3b_2 A_N B C VGND VNB VPB VPWR X
.ends

* Black-box entry subcircuit for sky130_fd_sc_hd__nand3_2 abstract view
.subckt sky130_fd_sc_hd__nand3_2 A B C VGND VNB VPB VPWR Y
.ends

* Black-box entry subcircuit for sky130_fd_sc_hd__clkbuf_8 abstract view
.subckt sky130_fd_sc_hd__clkbuf_8 A VGND VNB VPB VPWR X
.ends

* Black-box entry subcircuit for sky130_fd_sc_hd__a32o_1 abstract view
.subckt sky130_fd_sc_hd__a32o_1 A1 A2 A3 B1 B2 VGND VNB VPB VPWR X
.ends

* Black-box entry subcircuit for sky130_fd_sc_hd__a311o_1 abstract view
.subckt sky130_fd_sc_hd__a311o_1 A1 A2 A3 B1 C1 VGND VNB VPB VPWR X
.ends

* Black-box entry subcircuit for sky130_fd_sc_hd__a31oi_1 abstract view
.subckt sky130_fd_sc_hd__a31oi_1 A1 A2 A3 B1 VGND VNB VPB VPWR Y
.ends

* Black-box entry subcircuit for sky130_fd_sc_hd__nor3_1 abstract view
.subckt sky130_fd_sc_hd__nor3_1 A B C VGND VNB VPB VPWR Y
.ends

* Black-box entry subcircuit for sky130_fd_sc_hd__o32a_1 abstract view
.subckt sky130_fd_sc_hd__o32a_1 A1 A2 A3 B1 B2 VGND VNB VPB VPWR X
.ends

* Black-box entry subcircuit for sky130_fd_sc_hd__nor2_2 abstract view
.subckt sky130_fd_sc_hd__nor2_2 A B VGND VNB VPB VPWR Y
.ends

* Black-box entry subcircuit for sky130_fd_sc_hd__a22oi_2 abstract view
.subckt sky130_fd_sc_hd__a22oi_2 A1 A2 B1 B2 VGND VNB VPB VPWR Y
.ends

* Black-box entry subcircuit for sky130_fd_sc_hd__and2b_1 abstract view
.subckt sky130_fd_sc_hd__and2b_1 A_N B VGND VNB VPB VPWR X
.ends

* Black-box entry subcircuit for sky130_fd_sc_hd__or4_2 abstract view
.subckt sky130_fd_sc_hd__or4_2 A B C D VGND VNB VPB VPWR X
.ends

* Black-box entry subcircuit for sky130_fd_sc_hd__mux4_1 abstract view
.subckt sky130_fd_sc_hd__mux4_1 A0 A1 A2 A3 S0 S1 VGND VNB VPB VPWR X
.ends

* Black-box entry subcircuit for sky130_fd_sc_hd__dfxtp_2 abstract view
.subckt sky130_fd_sc_hd__dfxtp_2 CLK D VGND VNB VPB VPWR Q
.ends

* Black-box entry subcircuit for sky130_fd_sc_hd__nand3b_4 abstract view
.subckt sky130_fd_sc_hd__nand3b_4 A_N B C VGND VNB VPB VPWR Y
.ends

* Black-box entry subcircuit for sky130_fd_sc_hd__dfstp_1 abstract view
.subckt sky130_fd_sc_hd__dfstp_1 CLK D SET_B VGND VNB VPB VPWR Q
.ends

* Black-box entry subcircuit for sky130_fd_sc_hd__o221a_1 abstract view
.subckt sky130_fd_sc_hd__o221a_1 A1 A2 B1 B2 C1 VGND VNB VPB VPWR X
.ends

* Black-box entry subcircuit for sky130_fd_sc_hd__and4b_1 abstract view
.subckt sky130_fd_sc_hd__and4b_1 A_N B C D VGND VNB VPB VPWR X
.ends

* Black-box entry subcircuit for sky130_fd_sc_hd__o21ai_1 abstract view
.subckt sky130_fd_sc_hd__o21ai_1 A1 A2 B1 VGND VNB VPB VPWR Y
.ends

* Black-box entry subcircuit for sky130_fd_sc_hd__o221ai_1 abstract view
.subckt sky130_fd_sc_hd__o221ai_1 A1 A2 B1 B2 C1 VGND VNB VPB VPWR Y
.ends

* Black-box entry subcircuit for sky130_fd_sc_hd__o41a_1 abstract view
.subckt sky130_fd_sc_hd__o41a_1 A1 A2 A3 A4 B1 VGND VNB VPB VPWR X
.ends

* Black-box entry subcircuit for sky130_fd_sc_hd__o21ba_1 abstract view
.subckt sky130_fd_sc_hd__o21ba_1 A1 A2 B1_N VGND VNB VPB VPWR X
.ends

* Black-box entry subcircuit for sky130_fd_sc_hd__dfrtp_2 abstract view
.subckt sky130_fd_sc_hd__dfrtp_2 CLK D RESET_B VGND VNB VPB VPWR Q
.ends

* Black-box entry subcircuit for sky130_fd_sc_hd__or4b_1 abstract view
.subckt sky130_fd_sc_hd__or4b_1 A B C D_N VGND VNB VPB VPWR X
.ends

* Black-box entry subcircuit for sky130_fd_sc_hd__or4bb_1 abstract view
.subckt sky130_fd_sc_hd__or4bb_1 A B C_N D_N VGND VNB VPB VPWR X
.ends

* Black-box entry subcircuit for sky130_fd_sc_hd__and4_1 abstract view
.subckt sky130_fd_sc_hd__and4_1 A B C D VGND VNB VPB VPWR X
.ends

* Black-box entry subcircuit for sky130_fd_sc_hd__nand3_1 abstract view
.subckt sky130_fd_sc_hd__nand3_1 A B C VGND VNB VPB VPWR Y
.ends

* Black-box entry subcircuit for sky130_fd_sc_hd__o31a_1 abstract view
.subckt sky130_fd_sc_hd__o31a_1 A1 A2 A3 B1 VGND VNB VPB VPWR X
.ends

* Black-box entry subcircuit for sky130_fd_sc_hd__nand2b_1 abstract view
.subckt sky130_fd_sc_hd__nand2b_1 A_N B VGND VNB VPB VPWR Y
.ends

* Black-box entry subcircuit for sky130_fd_sc_hd__buf_4 abstract view
.subckt sky130_fd_sc_hd__buf_4 A VGND VNB VPB VPWR X
.ends

* Black-box entry subcircuit for sky130_fd_sc_hd__a31oi_2 abstract view
.subckt sky130_fd_sc_hd__a31oi_2 A1 A2 A3 B1 VGND VNB VPB VPWR Y
.ends

* Black-box entry subcircuit for sky130_fd_sc_hd__o2111a_1 abstract view
.subckt sky130_fd_sc_hd__o2111a_1 A1 A2 B1 C1 D1 VGND VNB VPB VPWR X
.ends

* Black-box entry subcircuit for sky130_fd_sc_hd__o31ai_1 abstract view
.subckt sky130_fd_sc_hd__o31ai_1 A1 A2 A3 B1 VGND VNB VPB VPWR Y
.ends

* Black-box entry subcircuit for sky130_fd_sc_hd__dlymetal6s2s_1 abstract view
.subckt sky130_fd_sc_hd__dlymetal6s2s_1 A VGND VNB VPB VPWR X
.ends

* Black-box entry subcircuit for sky130_fd_sc_hd__inv_6 abstract view
.subckt sky130_fd_sc_hd__inv_6 A VGND VNB VPB VPWR Y
.ends

* Black-box entry subcircuit for sky130_fd_sc_hd__a22o_2 abstract view
.subckt sky130_fd_sc_hd__a22o_2 A1 A2 B1 B2 VGND VNB VPB VPWR X
.ends

* Black-box entry subcircuit for sky130_fd_sc_hd__nor4_1 abstract view
.subckt sky130_fd_sc_hd__nor4_1 A B C D VGND VNB VPB VPWR Y
.ends

* Black-box entry subcircuit for sky130_fd_sc_hd__nand2_4 abstract view
.subckt sky130_fd_sc_hd__nand2_4 A B VGND VNB VPB VPWR Y
.ends

* Black-box entry subcircuit for sky130_fd_sc_hd__a221oi_1 abstract view
.subckt sky130_fd_sc_hd__a221oi_1 A1 A2 B1 B2 C1 VGND VNB VPB VPWR Y
.ends

* Black-box entry subcircuit for sky130_fd_sc_hd__o31a_2 abstract view
.subckt sky130_fd_sc_hd__o31a_2 A1 A2 A3 B1 VGND VNB VPB VPWR X
.ends

* Black-box entry subcircuit for sky130_fd_sc_hd__inv_8 abstract view
.subckt sky130_fd_sc_hd__inv_8 A VGND VNB VPB VPWR Y
.ends

* Black-box entry subcircuit for sky130_fd_sc_hd__o211ai_1 abstract view
.subckt sky130_fd_sc_hd__o211ai_1 A1 A2 B1 C1 VGND VNB VPB VPWR Y
.ends

* Black-box entry subcircuit for sky130_fd_sc_hd__nor2_4 abstract view
.subckt sky130_fd_sc_hd__nor2_4 A B VGND VNB VPB VPWR Y
.ends

* Black-box entry subcircuit for sky130_fd_sc_hd__buf_1 abstract view
.subckt sky130_fd_sc_hd__buf_1 A VGND VNB VPB VPWR X
.ends

* Black-box entry subcircuit for sky130_fd_sc_hd__clkinv_8 abstract view
.subckt sky130_fd_sc_hd__clkinv_8 A VGND VNB VPB VPWR Y
.ends

* Black-box entry subcircuit for sky130_fd_sc_hd__clkinvlp_4 abstract view
.subckt sky130_fd_sc_hd__clkinvlp_4 A VGND VNB VPB VPWR Y
.ends

* Black-box entry subcircuit for sky130_fd_sc_hd__nor3b_1 abstract view
.subckt sky130_fd_sc_hd__nor3b_1 A B C_N VGND VNB VPB VPWR Y
.ends

* Black-box entry subcircuit for sky130_fd_sc_hd__a21boi_1 abstract view
.subckt sky130_fd_sc_hd__a21boi_1 A1 A2 B1_N VGND VNB VPB VPWR Y
.ends

* Black-box entry subcircuit for sky130_fd_sc_hd__or3_2 abstract view
.subckt sky130_fd_sc_hd__or3_2 A B C VGND VNB VPB VPWR X
.ends

* Black-box entry subcircuit for sky130_fd_sc_hd__clkinv_4 abstract view
.subckt sky130_fd_sc_hd__clkinv_4 A VGND VNB VPB VPWR Y
.ends

* Black-box entry subcircuit for sky130_fd_sc_hd__nand3b_1 abstract view
.subckt sky130_fd_sc_hd__nand3b_1 A_N B C VGND VNB VPB VPWR Y
.ends

* Black-box entry subcircuit for sky130_fd_sc_hd__clkbuf_16 abstract view
.subckt sky130_fd_sc_hd__clkbuf_16 A VGND VNB VPB VPWR X
.ends

* Black-box entry subcircuit for sky130_fd_sc_hd__nor4_2 abstract view
.subckt sky130_fd_sc_hd__nor4_2 A B C D VGND VNB VPB VPWR Y
.ends

* Black-box entry subcircuit for sky130_fd_sc_hd__o21bai_1 abstract view
.subckt sky130_fd_sc_hd__o21bai_1 A1 A2 B1_N VGND VNB VPB VPWR Y
.ends

* Black-box entry subcircuit for sky130_fd_sc_hd__o21ai_4 abstract view
.subckt sky130_fd_sc_hd__o21ai_4 A1 A2 B1 VGND VNB VPB VPWR Y
.ends

* Black-box entry subcircuit for sky130_fd_sc_hd__nand4_1 abstract view
.subckt sky130_fd_sc_hd__nand4_1 A B C D VGND VNB VPB VPWR Y
.ends

* Black-box entry subcircuit for sky130_fd_sc_hd__bufinv_16 abstract view
.subckt sky130_fd_sc_hd__bufinv_16 A VGND VNB VPB VPWR Y
.ends

* Black-box entry subcircuit for sky130_fd_sc_hd__o211ai_4 abstract view
.subckt sky130_fd_sc_hd__o211ai_4 A1 A2 B1 C1 VGND VNB VPB VPWR Y
.ends

* Black-box entry subcircuit for sky130_fd_sc_hd__and3b_1 abstract view
.subckt sky130_fd_sc_hd__and3b_1 A_N B C VGND VNB VPB VPWR X
.ends

* Black-box entry subcircuit for sky130_fd_sc_hd__a211oi_1 abstract view
.subckt sky130_fd_sc_hd__a211oi_1 A1 A2 B1 C1 VGND VNB VPB VPWR Y
.ends

* Black-box entry subcircuit for sky130_fd_sc_hd__a21oi_2 abstract view
.subckt sky130_fd_sc_hd__a21oi_2 A1 A2 B1 VGND VNB VPB VPWR Y
.ends

* Black-box entry subcircuit for sky130_fd_sc_hd__nand4b_1 abstract view
.subckt sky130_fd_sc_hd__nand4b_1 A_N B C D VGND VNB VPB VPWR Y
.ends

* Black-box entry subcircuit for sky130_fd_sc_hd__or2_4 abstract view
.subckt sky130_fd_sc_hd__or2_4 A B VGND VNB VPB VPWR X
.ends

* Black-box entry subcircuit for sky130_fd_sc_hd__inv_12 abstract view
.subckt sky130_fd_sc_hd__inv_12 A VGND VNB VPB VPWR Y
.ends

* Black-box entry subcircuit for sky130_fd_sc_hd__a311oi_1 abstract view
.subckt sky130_fd_sc_hd__a311oi_1 A1 A2 A3 B1 C1 VGND VNB VPB VPWR Y
.ends

* Black-box entry subcircuit for sky130_fd_sc_hd__a32oi_4 abstract view
.subckt sky130_fd_sc_hd__a32oi_4 A1 A2 A3 B1 B2 VGND VNB VPB VPWR Y
.ends

* Black-box entry subcircuit for sky130_fd_sc_hd__o2bb2a_1 abstract view
.subckt sky130_fd_sc_hd__o2bb2a_1 A1_N A2_N B1 B2 VGND VNB VPB VPWR X
.ends

* Black-box entry subcircuit for sky130_fd_sc_hd__o2111ai_1 abstract view
.subckt sky130_fd_sc_hd__o2111ai_1 A1 A2 B1 C1 D1 VGND VNB VPB VPWR Y
.ends

* Black-box entry subcircuit for sky130_fd_sc_hd__nand2b_2 abstract view
.subckt sky130_fd_sc_hd__nand2b_2 A_N B VGND VNB VPB VPWR Y
.ends

* Black-box entry subcircuit for sky130_fd_sc_hd__nand3b_2 abstract view
.subckt sky130_fd_sc_hd__nand3b_2 A_N B C VGND VNB VPB VPWR Y
.ends

* Black-box entry subcircuit for sky130_fd_sc_hd__clkinv_2 abstract view
.subckt sky130_fd_sc_hd__clkinv_2 A VGND VNB VPB VPWR Y
.ends

* Black-box entry subcircuit for sky130_fd_sc_hd__inv_16 abstract view
.subckt sky130_fd_sc_hd__inv_16 A VGND VNB VPB VPWR Y
.ends

* Black-box entry subcircuit for sky130_fd_sc_hd__clkbuf_1 abstract view
.subckt sky130_fd_sc_hd__clkbuf_1 A VGND VNB VPB VPWR X
.ends

* Black-box entry subcircuit for sky130_fd_sc_hd__o22ai_1 abstract view
.subckt sky130_fd_sc_hd__o22ai_1 A1 A2 B1 B2 VGND VNB VPB VPWR Y
.ends

* Black-box entry subcircuit for sky130_fd_sc_hd__a22oi_1 abstract view
.subckt sky130_fd_sc_hd__a22oi_1 A1 A2 B1 B2 VGND VNB VPB VPWR Y
.ends

* Black-box entry subcircuit for sky130_fd_sc_hd__o31ai_4 abstract view
.subckt sky130_fd_sc_hd__o31ai_4 A1 A2 A3 B1 VGND VNB VPB VPWR Y
.ends

* Black-box entry subcircuit for sky130_fd_sc_hd__o21a_2 abstract view
.subckt sky130_fd_sc_hd__o21a_2 A1 A2 B1 VGND VNB VPB VPWR X
.ends

* Black-box entry subcircuit for sky130_fd_sc_hd__or4_4 abstract view
.subckt sky130_fd_sc_hd__or4_4 A B C D VGND VNB VPB VPWR X
.ends

* Black-box entry subcircuit for sky130_fd_sc_hd__o221ai_2 abstract view
.subckt sky130_fd_sc_hd__o221ai_2 A1 A2 B1 B2 C1 VGND VNB VPB VPWR Y
.ends

* Black-box entry subcircuit for sky130_fd_sc_hd__a311oi_4 abstract view
.subckt sky130_fd_sc_hd__a311oi_4 A1 A2 A3 B1 C1 VGND VNB VPB VPWR Y
.ends

* Black-box entry subcircuit for sky130_fd_sc_hd__and3b_4 abstract view
.subckt sky130_fd_sc_hd__and3b_4 A_N B C VGND VNB VPB VPWR X
.ends

* Black-box entry subcircuit for sky130_fd_sc_hd__a41o_2 abstract view
.subckt sky130_fd_sc_hd__a41o_2 A1 A2 A3 A4 B1 VGND VNB VPB VPWR X
.ends

* Black-box entry subcircuit for sky130_fd_sc_hd__nor3b_4 abstract view
.subckt sky130_fd_sc_hd__nor3b_4 A B C_N VGND VNB VPB VPWR Y
.ends

* Black-box entry subcircuit for sky130_fd_sc_hd__conb_1 abstract view
.subckt sky130_fd_sc_hd__conb_1 VGND VNB VPB VPWR HI LO
.ends

* Black-box entry subcircuit for sky130_fd_sc_hd__a21boi_2 abstract view
.subckt sky130_fd_sc_hd__a21boi_2 A1 A2 B1_N VGND VNB VPB VPWR Y
.ends

* Black-box entry subcircuit for sky130_fd_sc_hd__and3_2 abstract view
.subckt sky130_fd_sc_hd__and3_2 A B C VGND VNB VPB VPWR X
.ends

* Black-box entry subcircuit for sky130_fd_sc_hd__o2111a_4 abstract view
.subckt sky130_fd_sc_hd__o2111a_4 A1 A2 B1 C1 D1 VGND VNB VPB VPWR X
.ends

* Black-box entry subcircuit for sky130_fd_sc_hd__and4bb_1 abstract view
.subckt sky130_fd_sc_hd__and4bb_1 A_N B_N C D VGND VNB VPB VPWR X
.ends

* Black-box entry subcircuit for sky130_fd_sc_hd__or3b_4 abstract view
.subckt sky130_fd_sc_hd__or3b_4 A B C_N VGND VNB VPB VPWR X
.ends

* Black-box entry subcircuit for sky130_fd_sc_hd__and2_4 abstract view
.subckt sky130_fd_sc_hd__and2_4 A B VGND VNB VPB VPWR X
.ends

* Black-box entry subcircuit for sky130_fd_sc_hd__and4_4 abstract view
.subckt sky130_fd_sc_hd__and4_4 A B C D VGND VNB VPB VPWR X
.ends

* Black-box entry subcircuit for sky130_fd_sc_hd__and3_4 abstract view
.subckt sky130_fd_sc_hd__and3_4 A B C VGND VNB VPB VPWR X
.ends

* Black-box entry subcircuit for sky130_fd_sc_hd__o211ai_2 abstract view
.subckt sky130_fd_sc_hd__o211ai_2 A1 A2 B1 C1 VGND VNB VPB VPWR Y
.ends

* Black-box entry subcircuit for sky130_fd_sc_hd__or3b_2 abstract view
.subckt sky130_fd_sc_hd__or3b_2 A B C_N VGND VNB VPB VPWR X
.ends

* Black-box entry subcircuit for sky130_fd_sc_hd__o211a_2 abstract view
.subckt sky130_fd_sc_hd__o211a_2 A1 A2 B1 C1 VGND VNB VPB VPWR X
.ends

* Black-box entry subcircuit for sky130_fd_sc_hd__xnor2_2 abstract view
.subckt sky130_fd_sc_hd__xnor2_2 A B VGND VNB VPB VPWR Y
.ends

* Black-box entry subcircuit for sky130_fd_sc_hd__nand3_4 abstract view
.subckt sky130_fd_sc_hd__nand3_4 A B C VGND VNB VPB VPWR Y
.ends

* Black-box entry subcircuit for sky130_fd_sc_hd__or4bb_2 abstract view
.subckt sky130_fd_sc_hd__or4bb_2 A B C_N D_N VGND VNB VPB VPWR X
.ends

* Black-box entry subcircuit for sky130_fd_sc_hd__a311oi_2 abstract view
.subckt sky130_fd_sc_hd__a311oi_2 A1 A2 A3 B1 C1 VGND VNB VPB VPWR Y
.ends

* Black-box entry subcircuit for sky130_fd_sc_hd__and4_2 abstract view
.subckt sky130_fd_sc_hd__and4_2 A B C D VGND VNB VPB VPWR X
.ends

* Black-box entry subcircuit for sky130_fd_sc_hd__and4b_2 abstract view
.subckt sky130_fd_sc_hd__and4b_2 A_N B C D VGND VNB VPB VPWR X
.ends

* Black-box entry subcircuit for sky130_fd_sc_hd__a2bb2o_2 abstract view
.subckt sky130_fd_sc_hd__a2bb2o_2 A1_N A2_N B1 B2 VGND VNB VPB VPWR X
.ends

* Black-box entry subcircuit for sky130_fd_sc_hd__or4b_4 abstract view
.subckt sky130_fd_sc_hd__or4b_4 A B C D_N VGND VNB VPB VPWR X
.ends

.subckt tt_um_bfcpu VGND VPWR clk ena rst_n ui_in[0] ui_in[1] ui_in[2] ui_in[3] ui_in[4]
+ ui_in[5] ui_in[6] ui_in[7] uio_in[0] uio_in[1] uio_in[2] uio_in[3] uio_in[4] uio_in[5]
+ uio_in[6] uio_in[7] uio_oe[0] uio_oe[1] uio_oe[2] uio_oe[3] uio_oe[4] uio_oe[5]
+ uio_oe[6] uio_oe[7] uio_out[0] uio_out[1] uio_out[2] uio_out[3] uio_out[4] uio_out[5]
+ uio_out[6] uio_out[7] uo_out[0] uo_out[1] uo_out[2] uo_out[3] uo_out[4] uo_out[5]
+ uo_out[6] uo_out[7]
XFILLER_79_391 VGND VGND VPWR VPWR sky130_fd_sc_hd__fill_1
XFILLER_39_244 VPWR VGND VPWR VGND sky130_ef_sc_hd__decap_12
X_3155_ _5931_/Q _3144_/B _2977_/Y VGND VGND VPWR VPWR _3155_/X sky130_fd_sc_hd__a21o_1
XFILLER_55_704 VGND VGND VPWR VPWR sky130_fd_sc_hd__fill_1
XTAP_TAPCELL_ROW_68_1026 VGND VPWR sky130_fd_sc_hd__tapvpwrvgnd_1
X_3086_ _3086_/A _3086_/B _3086_/C _3086_/D VGND VGND VPWR VPWR _3087_/B sky130_fd_sc_hd__or4_1
XANTENNA__4640__A1 _4672_/A1 VGND VGND VPWR VPWR sky130_fd_sc_hd__diode_2
XFILLER_50_475 VGND VGND VPWR VPWR sky130_fd_sc_hd__fill_1
X_3988_ _4006_/S _3987_/Y _5623_/Q VGND VGND VPWR VPWR _3989_/A sky130_fd_sc_hd__mux2_1
X_5727_ _5966_/CLK _5727_/D fanout305/X VGND VGND VPWR VPWR _5727_/Q sky130_fd_sc_hd__dfrtp_4
X_2939_ _5490_/Q _2939_/B VGND VGND VPWR VPWR _2939_/X sky130_fd_sc_hd__or2_1
XTAP_TAPCELL_ROW_79_1166 VGND VPWR sky130_fd_sc_hd__tapvpwrvgnd_1
X_5658_ _5690_/CLK hold6/X VGND VGND VPWR VPWR hold16/A sky130_fd_sc_hd__dfxtp_1
X_4609_ hold185/X _4737_/A2 _4608_/X VGND VGND VPWR VPWR _5774_/D sky130_fd_sc_hd__o21a_1
X_5589_ _6120_/CLK _5589_/D fanout313/X VGND VGND VPWR VPWR _5589_/Q sky130_fd_sc_hd__dfrtp_1
Xhold340 _6039_/Q VGND VGND VPWR VPWR hold340/X sky130_fd_sc_hd__dlygate4sd3_1
Xhold362 _5969_/Q VGND VGND VPWR VPWR hold362/X sky130_fd_sc_hd__dlygate4sd3_1
Xhold351 _6135_/Q VGND VGND VPWR VPWR _5235_/A sky130_fd_sc_hd__dlygate4sd3_1
Xhold384 _5927_/Q VGND VGND VPWR VPWR hold384/X sky130_fd_sc_hd__dlygate4sd3_1
Xhold373 _5712_/Q VGND VGND VPWR VPWR hold373/X sky130_fd_sc_hd__dlygate4sd3_1
Xhold395 _5915_/Q VGND VGND VPWR VPWR hold395/X sky130_fd_sc_hd__dlygate4sd3_1
XANTENNA__4829__B _4829_/B VGND VGND VPWR VPWR sky130_fd_sc_hd__diode_2
XANTENNA__3225__S _3229_/S VGND VGND VPWR VPWR sky130_fd_sc_hd__diode_2
XANTENNA_fanout75_A _4870_/A1 VGND VGND VPWR VPWR sky130_fd_sc_hd__diode_2
XANTENNA__2890__B1 _2926_/B1 VGND VGND VPWR VPWR sky130_fd_sc_hd__diode_2
XANTENNA__4631__A1 _5760_/Q VGND VGND VPWR VPWR sky130_fd_sc_hd__diode_2
XFILLER_13_111 VGND VGND VPWR VPWR sky130_fd_sc_hd__fill_1
XFILLER_26_85 VGND VGND VPWR VPWR sky130_fd_sc_hd__fill_1
XFILLER_26_96 VGND VGND VPWR VPWR sky130_fd_sc_hd__fill_1
XANTENNA_fanout30_X _3783_/A VGND VGND VPWR VPWR sky130_fd_sc_hd__diode_2
XANTENNA__3198__A1 _5469_/Q VGND VGND VPWR VPWR sky130_fd_sc_hd__diode_2
XTAP_TAPCELL_ROW_11_323 VGND VPWR sky130_fd_sc_hd__tapvpwrvgnd_1
XTAP_TAPCELL_ROW_11_312 VGND VPWR sky130_fd_sc_hd__tapvpwrvgnd_1
XFILLER_5_321 VGND VGND VPWR VPWR sky130_fd_sc_hd__decap_4
XANTENNA__4698__A1 _2843_/B VGND VGND VPWR VPWR sky130_fd_sc_hd__diode_2
XANTENNA__3643__B _4444_/B VGND VGND VPWR VPWR sky130_fd_sc_hd__diode_2
XFILLER_76_350 VPWR VGND VPWR VGND sky130_ef_sc_hd__decap_12
XTAP_TAPCELL_ROW_19_412 VGND VPWR sky130_fd_sc_hd__tapvpwrvgnd_1
XTAP_TAPCELL_ROW_19_423 VGND VPWR sky130_fd_sc_hd__tapvpwrvgnd_1
XANTENNA__4870__A1 _4870_/A1 VGND VGND VPWR VPWR sky130_fd_sc_hd__diode_2
XTAP_TAPCELL_ROW_47_765 VGND VPWR sky130_fd_sc_hd__tapvpwrvgnd_1
XANTENNA__4622__A1 _4678_/A1 VGND VGND VPWR VPWR sky130_fd_sc_hd__diode_2
X_4960_ hold467/X _4975_/A2 _4959_/X VGND VGND VPWR VPWR _5929_/D sky130_fd_sc_hd__a21o_1
X_4891_ hold444/X _4948_/A2 _4890_/X VGND VGND VPWR VPWR _5906_/D sky130_fd_sc_hd__a21o_1
X_3911_ _5580_/Q _3910_/X _3917_/S VGND VGND VPWR VPWR _5580_/D sky130_fd_sc_hd__mux2_1
X_3842_ _5510_/Q _3913_/B VGND VGND VPWR VPWR _3842_/X sky130_fd_sc_hd__or2_1
XANTENNA__2936__A1 _5474_/Q VGND VGND VPWR VPWR sky130_fd_sc_hd__diode_2
X_3773_ _3773_/A _3773_/B VGND VGND VPWR VPWR _3773_/Y sky130_fd_sc_hd__nor2_1
X_5512_ _5811_/CLK _5512_/D fanout288/X VGND VGND VPWR VPWR _5512_/Q sky130_fd_sc_hd__dfrtp_1
XANTENNA__2936__B2 _4973_/A0 VGND VGND VPWR VPWR sky130_fd_sc_hd__diode_2
X_2724_ _5492_/Q VGND VGND VPWR VPWR _2724_/Y sky130_fd_sc_hd__inv_2
XFILLER_9_693 VPWR VGND VPWR VGND sky130_ef_sc_hd__decap_12
XFILLER_8_192 VGND VGND VPWR VPWR sky130_fd_sc_hd__decap_4
X_5443_ _5434_/X _5437_/Y _5442_/Y VGND VGND VPWR VPWR _5443_/X sky130_fd_sc_hd__o21a_1
X_5374_ _5369_/A _5441_/B _5373_/X VGND VGND VPWR VPWR _6164_/D sky130_fd_sc_hd__a21o_1
X_4325_ _4325_/A _4325_/B VGND VGND VPWR VPWR _4325_/X sky130_fd_sc_hd__or2_1
Xfanout105 _4878_/Y VGND VGND VPWR VPWR _4975_/A2 sky130_fd_sc_hd__clkbuf_4
Xfanout127 _4877_/X VGND VGND VPWR VPWR _4950_/B1 sky130_fd_sc_hd__clkbuf_4
Xfanout116 _3239_/Y VGND VGND VPWR VPWR _3663_/A sky130_fd_sc_hd__buf_2
XANTENNA__4368__C _5737_/Q VGND VGND VPWR VPWR sky130_fd_sc_hd__diode_2
X_4256_ _5700_/Q _4320_/B _4256_/C VGND VGND VPWR VPWR _4277_/S sky130_fd_sc_hd__nor3_2
Xfanout149 _4109_/C VGND VGND VPWR VPWR _3906_/A1 sky130_fd_sc_hd__clkbuf_4
X_3207_ _4973_/A0 _5733_/Q _3207_/S VGND VGND VPWR VPWR _5478_/D sky130_fd_sc_hd__mux2_1
XFILLER_74_309 VGND VGND VPWR VPWR sky130_fd_sc_hd__fill_1
X_4187_ _5937_/Q _4177_/C _4176_/C _5904_/Q VGND VGND VPWR VPWR _4187_/X sky130_fd_sc_hd__a22o_1
XFILLER_27_203 VGND VGND VPWR VPWR sky130_fd_sc_hd__fill_1
XFILLER_27_225 VGND VGND VPWR VPWR sky130_fd_sc_hd__decap_8
X_3138_ hold51/X _3138_/B VGND VGND VPWR VPWR _3141_/A sky130_fd_sc_hd__nand2_1
XANTENNA__2872__B1 _2927_/B1 VGND VGND VPWR VPWR sky130_fd_sc_hd__diode_2
XANTENNA__4613__A1 _5766_/Q VGND VGND VPWR VPWR sky130_fd_sc_hd__diode_2
XANTENNA_fanout165_X _4687_/S VGND VGND VPWR VPWR sky130_fd_sc_hd__diode_2
XFILLER_55_578 VGND VGND VPWR VPWR sky130_fd_sc_hd__fill_1
X_3069_ _5601_/Q _5650_/Q VGND VGND VPWR VPWR _3075_/B sky130_fd_sc_hd__xor2_1
XANTENNA__5199__C _5412_/A VGND VGND VPWR VPWR sky130_fd_sc_hd__diode_2
XFILLER_42_217 VGND VGND VPWR VPWR sky130_fd_sc_hd__fill_1
XFILLER_23_497 VGND VGND VPWR VPWR sky130_fd_sc_hd__decap_6
XANTENNA__3463__B _6131_/D VGND VGND VPWR VPWR sky130_fd_sc_hd__diode_2
Xhold170 _6097_/Q VGND VGND VPWR VPWR hold170/X sky130_fd_sc_hd__dlygate4sd3_1
Xhold192 _6088_/Q VGND VGND VPWR VPWR hold192/X sky130_fd_sc_hd__dlygate4sd3_1
Xhold181 _5804_/Q VGND VGND VPWR VPWR hold181/X sky130_fd_sc_hd__dlygate4sd3_1
XFILLER_77_125 VGND VGND VPWR VPWR sky130_fd_sc_hd__decap_4
XANTENNA_clkbuf_leaf_31_clk_A clkload2/A VGND VGND VPWR VPWR sky130_fd_sc_hd__diode_2
XANTENNA__5170__S _5170_/S VGND VGND VPWR VPWR sky130_fd_sc_hd__diode_2
XFILLER_46_567 VGND VGND VPWR VPWR sky130_fd_sc_hd__fill_1
XANTENNA_clkbuf_leaf_46_clk_A clkload1/A VGND VGND VPWR VPWR sky130_fd_sc_hd__diode_2
XFILLER_33_217 VGND VGND VPWR VPWR sky130_fd_sc_hd__decap_6
XANTENNA__4065__C1 _4542_/A VGND VGND VPWR VPWR sky130_fd_sc_hd__diode_2
XTAP_TAPCELL_ROW_44_724 VGND VPWR sky130_fd_sc_hd__tapvpwrvgnd_1
XTAP_TAPCELL_ROW_44_735 VGND VPWR sky130_fd_sc_hd__tapvpwrvgnd_1
XFILLER_53_83 VGND VGND VPWR VPWR sky130_fd_sc_hd__decap_4
XTAP_TAPCELL_ROW_24_481 VGND VPWR sky130_fd_sc_hd__tapvpwrvgnd_1
XANTENNA__2918__A1 _2895_/A VGND VGND VPWR VPWR sky130_fd_sc_hd__diode_2
XFILLER_10_692 VGND VGND VPWR VPWR sky130_fd_sc_hd__decap_8
XANTENNA__4540__B1 _4539_/X VGND VGND VPWR VPWR sky130_fd_sc_hd__diode_2
X_5090_ hold313/X _5473_/Q _5098_/S VGND VGND VPWR VPWR _6013_/D sky130_fd_sc_hd__mux2_1
XFILLER_78_80 VGND VGND VPWR VPWR sky130_fd_sc_hd__decap_4
XANTENNA__5096__A1 _5475_/Q VGND VGND VPWR VPWR sky130_fd_sc_hd__diode_2
XFILLER_68_136 VGND VGND VPWR VPWR sky130_fd_sc_hd__decap_4
X_4110_ _4866_/S _4109_/C _4865_/A _5566_/Q VGND VGND VPWR VPWR _4110_/X sky130_fd_sc_hd__a31o_1
XFILLER_68_147 VGND VGND VPWR VPWR sky130_fd_sc_hd__fill_1
X_4041_ _4074_/S1 _4040_/X _4039_/X _4542_/A VGND VGND VPWR VPWR _4041_/X sky130_fd_sc_hd__a211o_1
XANTENNA__5080__S _5097_/S VGND VGND VPWR VPWR sky130_fd_sc_hd__diode_2
XFILLER_49_361 VGND VGND VPWR VPWR sky130_fd_sc_hd__fill_1
X_5992_ _6115_/CLK _5992_/D fanout341/X VGND VGND VPWR VPWR _5992_/Q sky130_fd_sc_hd__dfrtp_1
X_4943_ _5472_/Q _4666_/X _4943_/S VGND VGND VPWR VPWR _4943_/X sky130_fd_sc_hd__mux2_1
X_4874_ _4874_/A _5185_/S VGND VGND VPWR VPWR _5902_/D sky130_fd_sc_hd__or2_1
XFILLER_32_283 VGND VGND VPWR VPWR sky130_fd_sc_hd__fill_1
X_3825_ _3773_/A _3822_/Y _3823_/X _3824_/Y VGND VGND VPWR VPWR _3825_/X sky130_fd_sc_hd__a31o_1
XANTENNA__3031__B1 _3138_/B VGND VGND VPWR VPWR sky130_fd_sc_hd__diode_2
X_3756_ _5566_/Q _5567_/Q _5568_/Q VGND VGND VPWR VPWR _3757_/B sky130_fd_sc_hd__a21oi_1
XANTENNA_fanout125_A _4877_/X VGND VGND VPWR VPWR sky130_fd_sc_hd__diode_2
XTAP_TAPCELL_ROW_76_1136 VGND VPWR sky130_fd_sc_hd__tapvpwrvgnd_1
XTAP_TAPCELL_ROW_76_1125 VGND VPWR sky130_fd_sc_hd__tapvpwrvgnd_1
X_3687_ _3715_/B _3714_/A _3715_/C _3716_/A VGND VGND VPWR VPWR _3687_/X sky130_fd_sc_hd__or4_1
XANTENNA__3564__A _3564_/A VGND VGND VPWR VPWR sky130_fd_sc_hd__diode_2
X_5426_ _5427_/A _5427_/B VGND VGND VPWR VPWR _5428_/A sky130_fd_sc_hd__nand2_1
XANTENNA__3334__A1 _5412_/A VGND VGND VPWR VPWR sky130_fd_sc_hd__diode_2
X_5357_ _5376_/B _5357_/B VGND VGND VPWR VPWR _5447_/B sky130_fd_sc_hd__and2_1
XANTENNA__3334__B2 _5201_/B VGND VGND VPWR VPWR sky130_fd_sc_hd__diode_2
X_4308_ _5713_/Q _4308_/A2 _4250_/Y _4307_/X VGND VGND VPWR VPWR _4308_/X sky130_fd_sc_hd__a22o_1
XPHY_EDGE_ROW_58_Left_139 VGND VGND VPWR VPWR sky130_fd_sc_hd__decap_3
X_5288_ _5288_/A _5288_/B VGND VGND VPWR VPWR _5289_/B sky130_fd_sc_hd__nand2_1
XANTENNA__5087__A1 _5470_/Q VGND VGND VPWR VPWR sky130_fd_sc_hd__diode_2
X_4239_ _5776_/Q _4169_/X _4238_/X _3192_/B VGND VGND VPWR VPWR _4239_/X sky130_fd_sc_hd__o211a_1
XANTENNA__4395__A _4408_/A VGND VGND VPWR VPWR sky130_fd_sc_hd__diode_2
XFILLER_74_49 VGND VGND VPWR VPWR sky130_fd_sc_hd__decap_8
XANTENNA__4047__C1 _4542_/A VGND VGND VPWR VPWR sky130_fd_sc_hd__diode_2
XFILLER_43_515 VGND VGND VPWR VPWR sky130_fd_sc_hd__fill_2
XANTENNA__4598__B1 _4686_/B1 VGND VGND VPWR VPWR sky130_fd_sc_hd__diode_2
XPHY_EDGE_ROW_67_Left_148 VGND VGND VPWR VPWR sky130_fd_sc_hd__decap_3
XANTENNA__5727__Q _5727_/Q VGND VGND VPWR VPWR sky130_fd_sc_hd__diode_2
XANTENNA__2930__X _2930_/X VGND VGND VPWR VPWR sky130_fd_sc_hd__diode_2
XFILLER_7_449 VGND VGND VPWR VPWR sky130_fd_sc_hd__decap_4
XTAP_TAPCELL_ROW_21_440 VGND VPWR sky130_fd_sc_hd__tapvpwrvgnd_1
X_2769__1 _3182_/A1 VGND VGND VPWR VPWR _5729_/CLK sky130_fd_sc_hd__inv_2
XANTENNA__5165__S _5167_/S VGND VGND VPWR VPWR sky130_fd_sc_hd__diode_2
XANTENNA__3193__B _5719_/Q VGND VGND VPWR VPWR sky130_fd_sc_hd__diode_2
XPHY_EDGE_ROW_76_Left_157 VGND VGND VPWR VPWR sky130_fd_sc_hd__decap_3
XANTENNA__5078__A1 _5489_/Q VGND VGND VPWR VPWR sky130_fd_sc_hd__diode_2
XFILLER_65_117 VGND VGND VPWR VPWR sky130_fd_sc_hd__fill_1
XANTENNA__2818__A _5754_/Q VGND VGND VPWR VPWR sky130_fd_sc_hd__diode_2
XANTENNA__4592__X _4592_/X VGND VGND VPWR VPWR sky130_fd_sc_hd__diode_2
XFILLER_0_57 VPWR VGND VPWR VGND sky130_ef_sc_hd__decap_12
XTAP_TAPCELL_ROW_29_540 VGND VPWR sky130_fd_sc_hd__tapvpwrvgnd_1
XANTENNA__2931__S0 _6114_/Q VGND VGND VPWR VPWR sky130_fd_sc_hd__diode_2
XTAP_TAPCELL_ROW_57_893 VGND VPWR sky130_fd_sc_hd__tapvpwrvgnd_1
XANTENNA__3649__A _4464_/A VGND VGND VPWR VPWR sky130_fd_sc_hd__diode_2
XANTENNA__3001__X _6137_/D VGND VGND VPWR VPWR sky130_fd_sc_hd__diode_2
XFILLER_42_581 VGND VGND VPWR VPWR sky130_fd_sc_hd__fill_1
X_4590_ _4686_/A1 _4589_/X _4678_/C1 VGND VGND VPWR VPWR _4590_/X sky130_fd_sc_hd__o21a_1
X_3610_ _3714_/B _3714_/C VGND VGND VPWR VPWR _3691_/C sky130_fd_sc_hd__or2_1
XANTENNA__2840__X _6128_/D VGND VGND VPWR VPWR sky130_fd_sc_hd__diode_2
X_3541_ _3562_/C _3562_/D VGND VGND VPWR VPWR _3541_/Y sky130_fd_sc_hd__nand2_2
XANTENNA__4761__B1 _4828_/B2 VGND VGND VPWR VPWR sky130_fd_sc_hd__diode_2
XANTENNA__5075__S _5098_/S VGND VGND VPWR VPWR sky130_fd_sc_hd__diode_2
XFILLER_6_471 VGND VGND VPWR VPWR sky130_fd_sc_hd__decap_4
XFILLER_50_3 VPWR VGND VPWR VGND sky130_ef_sc_hd__decap_12
X_3472_ _3472_/A _4350_/B VGND VGND VPWR VPWR _5230_/A sky130_fd_sc_hd__nor2_1
X_5211_ _5211_/A _5211_/B VGND VGND VPWR VPWR _5211_/X sky130_fd_sc_hd__or2_1
X_5142_ hold205/X _5518_/Q _5166_/S VGND VGND VPWR VPWR _6064_/D sky130_fd_sc_hd__mux2_1
XTAP_TAPCELL_ROW_71_1066 VGND VPWR sky130_fd_sc_hd__tapvpwrvgnd_1
X_5073_ hold227/X _5522_/Q _5097_/S VGND VGND VPWR VPWR _5996_/D sky130_fd_sc_hd__mux2_1
XANTENNA__4816__A1 _4427_/A VGND VGND VPWR VPWR sky130_fd_sc_hd__diode_2
X_4024_ _5653_/Q _5654_/Q _4024_/C VGND VGND VPWR VPWR _4027_/B sky130_fd_sc_hd__and3_1
XFILLER_64_194 VGND VGND VPWR VPWR sky130_fd_sc_hd__fill_2
XFILLER_25_559 VGND VGND VPWR VPWR sky130_fd_sc_hd__fill_1
X_5975_ clkload3/A _5975_/D fanout272/X VGND VGND VPWR VPWR _5975_/Q sky130_fd_sc_hd__dfrtp_1
X_4926_ _4623_/X _4950_/A2 _4950_/B1 _4925_/X VGND VGND VPWR VPWR _4926_/X sky130_fd_sc_hd__a22o_1
XANTENNA_fanout242_A _2744_/A VGND VGND VPWR VPWR sky130_fd_sc_hd__diode_2
XFILLER_40_529 VGND VGND VPWR VPWR sky130_fd_sc_hd__fill_1
X_4857_ _2824_/C hold259/X _4864_/S VGND VGND VPWR VPWR _5891_/D sky130_fd_sc_hd__mux2_1
XFILLER_20_220 VGND VGND VPWR VPWR sky130_fd_sc_hd__decap_3
XANTENNA__3278__B _5377_/A VGND VGND VPWR VPWR sky130_fd_sc_hd__diode_2
XFILLER_60_29 VGND VGND VPWR VPWR sky130_fd_sc_hd__fill_1
XFILLER_20_253 VGND VGND VPWR VPWR sky130_fd_sc_hd__decap_8
X_3808_ _5397_/A _3845_/B _3893_/C VGND VGND VPWR VPWR _3808_/X sky130_fd_sc_hd__and3_1
X_4788_ _5488_/Q hold246/X _4810_/S VGND VGND VPWR VPWR _5825_/D sky130_fd_sc_hd__mux2_1
XFILLER_20_297 VGND VGND VPWR VPWR sky130_fd_sc_hd__fill_1
XANTENNA__2910__B _2910_/B VGND VGND VPWR VPWR sky130_fd_sc_hd__diode_2
X_3739_ _5566_/Q _3738_/X _3759_/S VGND VGND VPWR VPWR _5566_/D sky130_fd_sc_hd__mux2_1
XFILLER_4_419 VGND VGND VPWR VPWR sky130_fd_sc_hd__fill_1
XANTENNA__3725__C _3725_/C VGND VGND VPWR VPWR sky130_fd_sc_hd__diode_2
XFILLER_0_603 VGND VGND VPWR VPWR sky130_fd_sc_hd__fill_1
X_5409_ _5409_/A _5409_/B _5409_/C VGND VGND VPWR VPWR _5410_/B sky130_fd_sc_hd__or3_1
XTAP_TAPCELL_ROW_7_268 VGND VPWR sky130_fd_sc_hd__tapvpwrvgnd_1
XFILLER_0_669 VGND VGND VPWR VPWR sky130_fd_sc_hd__decap_3
XFILLER_16_548 VGND VGND VPWR VPWR sky130_fd_sc_hd__decap_8
XTAP_TAPCELL_ROW_26_510 VGND VPWR sky130_fd_sc_hd__tapvpwrvgnd_1
XTAP_TAPCELL_ROW_54_852 VGND VPWR sky130_fd_sc_hd__tapvpwrvgnd_1
XANTENNA__2804__C _2895_/A VGND VGND VPWR VPWR sky130_fd_sc_hd__diode_2
XANTENNA_fanout7_X _5458_/C VGND VGND VPWR VPWR sky130_fd_sc_hd__diode_2
XANTENNA__4743__A0 _5766_/Q VGND VGND VPWR VPWR sky130_fd_sc_hd__diode_2
XFILLER_7_235 VGND VGND VPWR VPWR sky130_fd_sc_hd__fill_2
XFILLER_3_430 VPWR VGND VPWR VGND sky130_ef_sc_hd__decap_12
XFILLER_78_242 VGND VGND VPWR VPWR sky130_fd_sc_hd__fill_1
XANTENNA__3651__B _3651_/B VGND VGND VPWR VPWR sky130_fd_sc_hd__diode_2
XFILLER_19_331 VGND VGND VPWR VPWR sky130_fd_sc_hd__decap_4
XFILLER_74_492 VGND VGND VPWR VPWR sky130_fd_sc_hd__fill_1
XFILLER_62_632 VGND VGND VPWR VPWR sky130_fd_sc_hd__fill_1
XANTENNA__5909__RESET_B fanout306/X VGND VGND VPWR VPWR sky130_fd_sc_hd__diode_2
XFILLER_22_529 VGND VGND VPWR VPWR sky130_fd_sc_hd__fill_1
X_5760_ _6111_/CLK _5760_/D fanout327/X VGND VGND VPWR VPWR _5760_/Q sky130_fd_sc_hd__dfrtp_4
X_2972_ _3128_/B _3130_/A VGND VGND VPWR VPWR _2972_/Y sky130_fd_sc_hd__nand2_1
XANTENNA__4982__B1 _5038_/B1 VGND VGND VPWR VPWR sky130_fd_sc_hd__diode_2
X_4711_ _5762_/Q _5929_/Q _4735_/S VGND VGND VPWR VPWR _4711_/X sky130_fd_sc_hd__mux2_1
X_5691_ _5697_/CLK _5691_/D VGND VGND VPWR VPWR hold90/A sky130_fd_sc_hd__dfxtp_1
X_4642_ _5469_/Q _5795_/Q _4682_/S VGND VGND VPWR VPWR _4642_/X sky130_fd_sc_hd__mux2_1
XANTENNA__3666__X _5187_/B VGND VGND VPWR VPWR sky130_fd_sc_hd__diode_2
XTAP_TAPCELL_ROW_32_579 VGND VPWR sky130_fd_sc_hd__tapvpwrvgnd_1
X_4573_ _5945_/Q _5761_/Q _4623_/S VGND VGND VPWR VPWR _4573_/X sky130_fd_sc_hd__mux2_1
Xfanout7 _4291_/S VGND VGND VPWR VPWR _5458_/C sky130_fd_sc_hd__clkbuf_4
X_3524_ _3522_/X _3523_/Y _3515_/Y VGND VGND VPWR VPWR _3547_/A sky130_fd_sc_hd__a21oi_1
X_3455_ _6127_/Q _3455_/B _6126_/Q VGND VGND VPWR VPWR _3483_/A sky130_fd_sc_hd__or3b_1
X_6174_ clkload7/A _6174_/D fanout286/X VGND VGND VPWR VPWR _6174_/Q sky130_fd_sc_hd__dfrtp_4
X_3386_ _5986_/Q _6030_/Q _3394_/S VGND VGND VPWR VPWR _3386_/X sky130_fd_sc_hd__mux2_1
XTAP_TAPCELL_ROW_4_227 VGND VPWR sky130_fd_sc_hd__tapvpwrvgnd_1
X_5125_ _3130_/A _5189_/A2 _5863_/D _6163_/Q VGND VGND VPWR VPWR _6048_/D sky130_fd_sc_hd__a22o_1
X_5056_ _5980_/Q _5200_/C _5066_/S VGND VGND VPWR VPWR _5980_/D sky130_fd_sc_hd__mux2_1
X_4007_ _5646_/Q hold9/A _5675_/Q VGND VGND VPWR VPWR _5646_/D sky130_fd_sc_hd__mux2_1
XANTENNA__4670__C1 _4750_/C1 VGND VGND VPWR VPWR sky130_fd_sc_hd__diode_2
XFILLER_25_301 VGND VGND VPWR VPWR sky130_fd_sc_hd__fill_1
X_5958_ _5963_/CLK _5958_/D fanout308/X VGND VGND VPWR VPWR _5958_/Q sky130_fd_sc_hd__dfrtp_1
XANTENNA__3225__A0 _2934_/B VGND VGND VPWR VPWR sky130_fd_sc_hd__diode_2
XTAP_TAPCELL_ROW_51_822 VGND VPWR sky130_fd_sc_hd__tapvpwrvgnd_1
XANTENNA_fanout245_X _4447_/B VGND VGND VPWR VPWR sky130_fd_sc_hd__diode_2
XFILLER_71_39 VPWR VGND VPWR VGND sky130_ef_sc_hd__decap_12
XANTENNA__4973__A0 _4973_/A0 VGND VGND VPWR VPWR sky130_fd_sc_hd__diode_2
X_4909_ hold420/X _4951_/A2 _4908_/X VGND VGND VPWR VPWR _5912_/D sky130_fd_sc_hd__a21o_1
XFILLER_40_337 VGND VGND VPWR VPWR sky130_fd_sc_hd__fill_1
X_5889_ _6021_/CLK _5889_/D fanout333/X VGND VGND VPWR VPWR _5889_/Q sky130_fd_sc_hd__dfrtp_1
XANTENNA__4725__A0 _5764_/Q VGND VGND VPWR VPWR sky130_fd_sc_hd__diode_2
XFILLER_21_584 VGND VGND VPWR VPWR sky130_fd_sc_hd__fill_1
XANTENNA__3228__S _3229_/S VGND VGND VPWR VPWR sky130_fd_sc_hd__diode_2
XFILLER_0_433 VPWR VGND VPWR VGND sky130_ef_sc_hd__decap_12
XTAP_TAPCELL_ROW_59_922 VGND VPWR sky130_fd_sc_hd__tapvpwrvgnd_1
Xhold41 hold41/A VGND VGND VPWR VPWR hold41/X sky130_fd_sc_hd__dlygate4sd3_1
Xhold30 hold30/A VGND VGND VPWR VPWR hold30/X sky130_fd_sc_hd__dlygate4sd3_1
XANTENNA_fanout60_X _4747_/A2 VGND VGND VPWR VPWR sky130_fd_sc_hd__diode_2
Xhold74 hold74/A VGND VGND VPWR VPWR hold74/X sky130_fd_sc_hd__dlygate4sd3_1
XFILLER_29_85 VGND VGND VPWR VPWR sky130_fd_sc_hd__decap_4
Xhold63 hold63/A VGND VGND VPWR VPWR hold63/X sky130_fd_sc_hd__dlygate4sd3_1
Xhold52 hold52/A VGND VGND VPWR VPWR hold52/X sky130_fd_sc_hd__dlygate4sd3_1
Xhold96 hold96/A VGND VGND VPWR VPWR hold96/X sky130_fd_sc_hd__dlygate4sd3_1
Xhold85 hold85/A VGND VGND VPWR VPWR hold85/X sky130_fd_sc_hd__dlygate4sd3_1
XFILLER_44_643 VGND VGND VPWR VPWR sky130_fd_sc_hd__fill_1
XFILLER_31_315 VGND VGND VPWR VPWR sky130_fd_sc_hd__decap_4
XANTENNA__4964__A0 _4964_/A0 VGND VGND VPWR VPWR sky130_fd_sc_hd__diode_2
XFILLER_31_337 VGND VGND VPWR VPWR sky130_fd_sc_hd__decap_4
XANTENNA__3927__A _6129_/D VGND VGND VPWR VPWR sky130_fd_sc_hd__diode_2
XFILLER_61_83 VGND VGND VPWR VPWR sky130_fd_sc_hd__fill_2
XFILLER_12_584 VGND VGND VPWR VPWR sky130_fd_sc_hd__decap_4
XFILLER_8_544 VGND VGND VPWR VPWR sky130_fd_sc_hd__decap_3
XANTENNA__4716__B1 _4243_/S VGND VGND VPWR VPWR sky130_fd_sc_hd__diode_2
XFILLER_3_293 VPWR VGND VPWR VGND sky130_ef_sc_hd__decap_12
X_3240_ _3240_/A _3240_/B VGND VGND VPWR VPWR _3240_/X sky130_fd_sc_hd__or2_1
X_3171_ hold440/X _2965_/X _3168_/X _3170_/X VGND VGND VPWR VPWR _6142_/D sky130_fd_sc_hd__o22a_1
XFILLER_13_3 VPWR VGND VPWR VGND sky130_ef_sc_hd__decap_12
XTAP_TAPCELL_ROW_37_638 VGND VPWR sky130_fd_sc_hd__tapvpwrvgnd_1
XANTENNA__3207__A0 _4973_/A0 VGND VGND VPWR VPWR sky130_fd_sc_hd__diode_2
XFILLER_34_175 VPWR VGND VPWR VGND sky130_ef_sc_hd__decap_12
X_5812_ _6050_/CLK _5812_/D fanout290/X VGND VGND VPWR VPWR _5812_/Q sky130_fd_sc_hd__dfrtp_1
XTAP_TAPCELL_ROW_17_395 VGND VPWR sky130_fd_sc_hd__tapvpwrvgnd_1
X_5743_ clkload8/A _5743_/D fanout284/X VGND VGND VPWR VPWR _5743_/Q sky130_fd_sc_hd__dfrtp_1
XANTENNA__4955__A0 _2843_/B VGND VGND VPWR VPWR sky130_fd_sc_hd__diode_2
X_2955_ _2734_/Y _3426_/D _2954_/X VGND VGND VPWR VPWR _2955_/Y sky130_fd_sc_hd__o21ai_2
X_2886_ _5897_/Q _2886_/B VGND VGND VPWR VPWR _2886_/Y sky130_fd_sc_hd__nand2_1
X_5674_ _5690_/CLK _5674_/D VGND VGND VPWR VPWR hold3/A sky130_fd_sc_hd__dfxtp_1
XFILLER_30_392 VGND VGND VPWR VPWR sky130_fd_sc_hd__fill_1
X_4625_ hold301/X _4753_/A2 _4624_/X VGND VGND VPWR VPWR _5776_/D sky130_fd_sc_hd__o21a_1
XANTENNA__4707__B1 _4747_/B1 VGND VGND VPWR VPWR sky130_fd_sc_hd__diode_2
XANTENNA__4183__A1 _5761_/Q VGND VGND VPWR VPWR sky130_fd_sc_hd__diode_2
X_4556_ _5764_/Q _5174_/A2 _3544_/X _4551_/X VGND VGND VPWR VPWR _5764_/D sky130_fd_sc_hd__a22o_1
XANTENNA_fanout205_A _2871_/B VGND VGND VPWR VPWR sky130_fd_sc_hd__diode_2
X_3507_ _6120_/D _3517_/B _3492_/X _6141_/D VGND VGND VPWR VPWR _3509_/B sky130_fd_sc_hd__a22o_1
X_4487_ _4487_/A _4487_/B _4487_/C VGND VGND VPWR VPWR _4522_/D sky130_fd_sc_hd__and3_1
X_3438_ hold64/X _5585_/Q _3442_/S VGND VGND VPWR VPWR _5552_/D sky130_fd_sc_hd__mux2_1
X_6157_ _6159_/CLK _6157_/D fanout282/X VGND VGND VPWR VPWR _6157_/Q sky130_fd_sc_hd__dfrtp_1
X_3369_ _3880_/B VGND VGND VPWR VPWR _3369_/Y sky130_fd_sc_hd__inv_2
XFILLER_57_223 VGND VGND VPWR VPWR sky130_fd_sc_hd__fill_1
X_5108_ hold434/X _5201_/B _5127_/B VGND VGND VPWR VPWR _6031_/D sky130_fd_sc_hd__mux2_1
XANTENNA__4238__A2 _4167_/Y VGND VGND VPWR VPWR sky130_fd_sc_hd__diode_2
X_6088_ _6088_/CLK _6088_/D fanout338/X VGND VGND VPWR VPWR _6088_/Q sky130_fd_sc_hd__dfrtp_1
X_5039_ _5965_/Q _5043_/A2 _5038_/X VGND VGND VPWR VPWR _5965_/D sky130_fd_sc_hd__a21o_1
XTAP_TAPCELL_ROW_64_980 VGND VPWR sky130_fd_sc_hd__tapvpwrvgnd_1
XFILLER_80_281 VGND VGND VPWR VPWR sky130_fd_sc_hd__fill_1
XANTENNA__4946__A0 _5473_/Q VGND VGND VPWR VPWR sky130_fd_sc_hd__diode_2
XFILLER_13_337 VGND VGND VPWR VPWR sky130_fd_sc_hd__decap_6
XFILLER_40_123 VGND VGND VPWR VPWR sky130_fd_sc_hd__fill_1
XFILLER_5_558 VGND VGND VPWR VPWR sky130_fd_sc_hd__fill_2
XANTENNA__3921__B2 _3918_/X VGND VGND VPWR VPWR sky130_fd_sc_hd__diode_2
XANTENNA__5470__Q _5470_/Q VGND VGND VPWR VPWR sky130_fd_sc_hd__diode_2
XFILLER_17_632 VGND VGND VPWR VPWR sky130_fd_sc_hd__fill_1
XTAP_TAPCELL_ROW_34_608 VGND VPWR sky130_fd_sc_hd__tapvpwrvgnd_1
XANTENNA__4937__A0 _5470_/Q VGND VGND VPWR VPWR sky130_fd_sc_hd__diode_2
XFILLER_16_197 VGND VGND VPWR VPWR sky130_fd_sc_hd__decap_6
XANTENNA__3657__A _4399_/A VGND VGND VPWR VPWR sky130_fd_sc_hd__diode_2
XTAP_TAPCELL_ROW_14_354 VGND VPWR sky130_fd_sc_hd__tapvpwrvgnd_1
X_2740_ _6062_/Q VGND VGND VPWR VPWR _4561_/A sky130_fd_sc_hd__inv_2
XANTENNA__4165__A1 _5760_/Q VGND VGND VPWR VPWR sky130_fd_sc_hd__diode_2
X_4410_ _4527_/S _4406_/X _4409_/X VGND VGND VPWR VPWR _4410_/Y sky130_fd_sc_hd__a21oi_1
X_5390_ _6167_/Q _5442_/B VGND VGND VPWR VPWR _5390_/X sky130_fd_sc_hd__and2_1
X_4341_ hold279/X _4321_/X _4338_/C _4340_/C VGND VGND VPWR VPWR _5735_/D sky130_fd_sc_hd__a31o_1
Xfanout309 input1/X VGND VGND VPWR VPWR fanout309/X sky130_fd_sc_hd__clkbuf_2
X_4272_ _4191_/Y _4271_/X _5458_/C VGND VGND VPWR VPWR _4272_/X sky130_fd_sc_hd__mux2_1
X_6011_ _6085_/CLK _6011_/D fanout342/X VGND VGND VPWR VPWR _6011_/Q sky130_fd_sc_hd__dfrtp_1
X_3223_ _2843_/B _5488_/Q _3229_/S VGND VGND VPWR VPWR _5488_/D sky130_fd_sc_hd__mux2_1
XANTENNA__3125__C1 _2965_/X VGND VGND VPWR VPWR sky130_fd_sc_hd__diode_2
XFILLER_39_223 VGND VGND VPWR VPWR sky130_fd_sc_hd__fill_1
X_3154_ _5956_/Q _2971_/X _2973_/X _5964_/Q _2968_/X VGND VGND VPWR VPWR _3154_/X
+ sky130_fd_sc_hd__a221o_1
XFILLER_39_256 VPWR VGND VPWR VGND sky130_ef_sc_hd__decap_12
XTAP_TAPCELL_ROW_68_1027 VGND VPWR sky130_fd_sc_hd__tapvpwrvgnd_1
X_3085_ _5594_/Q _5680_/Q VGND VGND VPWR VPWR _3086_/D sky130_fd_sc_hd__xor2_1
XANTENNA__4928__A0 _5467_/Q VGND VGND VPWR VPWR sky130_fd_sc_hd__diode_2
XFILLER_62_292 VGND VGND VPWR VPWR sky130_fd_sc_hd__fill_1
XFILLER_50_421 VGND VGND VPWR VPWR sky130_fd_sc_hd__fill_1
XFILLER_23_657 VGND VGND VPWR VPWR sky130_fd_sc_hd__decap_3
XANTENNA_fanout155_A _3240_/A VGND VGND VPWR VPWR sky130_fd_sc_hd__diode_2
X_3987_ _4006_/S _3996_/A VGND VGND VPWR VPWR _3987_/Y sky130_fd_sc_hd__nand2_1
XANTENNA__2742__Y _4399_/A VGND VGND VPWR VPWR sky130_fd_sc_hd__diode_2
X_5726_ _5966_/CLK _5726_/D fanout304/X VGND VGND VPWR VPWR _5726_/Q sky130_fd_sc_hd__dfrtp_4
X_2938_ _2937_/B _2935_/X _2936_/X _2937_/Y VGND VGND VPWR VPWR _2938_/X sky130_fd_sc_hd__a31o_1
XTAP_TAPCELL_ROW_79_1167 VGND VPWR sky130_fd_sc_hd__tapvpwrvgnd_1
X_2869_ _5992_/Q _2783_/X _2785_/X VGND VGND VPWR VPWR _2869_/X sky130_fd_sc_hd__a21bo_1
X_5657_ _5690_/CLK hold99/X VGND VGND VPWR VPWR hold6/A sky130_fd_sc_hd__dfxtp_1
X_4608_ _4672_/A1 _4606_/X _4607_/X _4704_/C1 VGND VGND VPWR VPWR _4608_/X sky130_fd_sc_hd__a211o_1
X_5588_ _5682_/CLK _5588_/D fanout321/X VGND VGND VPWR VPWR _5588_/Q sky130_fd_sc_hd__dfrtp_1
Xhold330 _6035_/Q VGND VGND VPWR VPWR hold330/X sky130_fd_sc_hd__dlygate4sd3_1
Xhold341 _6054_/Q VGND VGND VPWR VPWR hold341/X sky130_fd_sc_hd__dlygate4sd3_1
Xhold352 _6053_/Q VGND VGND VPWR VPWR hold352/X sky130_fd_sc_hd__dlygate4sd3_1
X_4539_ _4539_/A _4539_/B VGND VGND VPWR VPWR _4539_/X sky130_fd_sc_hd__and2_2
Xhold396 _5934_/Q VGND VGND VPWR VPWR hold396/X sky130_fd_sc_hd__dlygate4sd3_1
Xhold374 _5926_/Q VGND VGND VPWR VPWR hold374/X sky130_fd_sc_hd__dlygate4sd3_1
Xhold385 _5635_/Q VGND VGND VPWR VPWR hold385/X sky130_fd_sc_hd__dlygate4sd3_1
XANTENNA__4829__C _4829_/C VGND VGND VPWR VPWR sky130_fd_sc_hd__diode_2
Xhold363 _5465_/Q VGND VGND VPWR VPWR _3186_/A sky130_fd_sc_hd__dlygate4sd3_1
XFILLER_18_407 VGND VGND VPWR VPWR sky130_fd_sc_hd__decap_8
XANTENNA__4616__C1 _4704_/C1 VGND VGND VPWR VPWR sky130_fd_sc_hd__diode_2
XFILLER_26_473 VGND VGND VPWR VPWR sky130_fd_sc_hd__decap_3
XANTENNA__4919__A0 _5492_/Q VGND VGND VPWR VPWR sky130_fd_sc_hd__diode_2
XFILLER_53_281 VGND VGND VPWR VPWR sky130_fd_sc_hd__fill_1
XANTENNA__5168__S _5172_/S VGND VGND VPWR VPWR sky130_fd_sc_hd__diode_2
XFILLER_13_167 VGND VGND VPWR VPWR sky130_fd_sc_hd__fill_1
XTAP_TAPCELL_ROW_11_313 VGND VPWR sky130_fd_sc_hd__tapvpwrvgnd_1
XFILLER_42_85 VGND VGND VPWR VPWR sky130_fd_sc_hd__decap_6
XANTENNA_clkbuf_leaf_5_clk_A clkload0/A VGND VGND VPWR VPWR sky130_fd_sc_hd__diode_2
XANTENNA__4800__S _4805_/S VGND VGND VPWR VPWR sky130_fd_sc_hd__diode_2
XFILLER_1_550 VGND VGND VPWR VPWR sky130_fd_sc_hd__fill_1
XFILLER_1_594 VGND VGND VPWR VPWR sky130_fd_sc_hd__fill_1
XFILLER_3_57 VGND VGND VPWR VPWR sky130_fd_sc_hd__decap_6
XFILLER_76_395 VGND VGND VPWR VPWR sky130_fd_sc_hd__decap_3
XFILLER_76_362 VGND VGND VPWR VPWR sky130_fd_sc_hd__fill_2
XANTENNA__2881__A1 _2895_/A VGND VGND VPWR VPWR sky130_fd_sc_hd__diode_2
XTAP_TAPCELL_ROW_19_413 VGND VPWR sky130_fd_sc_hd__tapvpwrvgnd_1
XANTENNA__4607__C1 _4678_/C1 VGND VGND VPWR VPWR sky130_fd_sc_hd__diode_2
XFILLER_36_237 VPWR VGND VPWR VGND sky130_ef_sc_hd__decap_12
XTAP_TAPCELL_ROW_47_766 VGND VPWR sky130_fd_sc_hd__tapvpwrvgnd_1
X_4890_ _4205_/X _4971_/A2 _4971_/B1 _4889_/X VGND VGND VPWR VPWR _4890_/X sky130_fd_sc_hd__a22o_1
X_3910_ _3758_/S _3907_/X _3912_/B _3909_/X VGND VGND VPWR VPWR _3910_/X sky130_fd_sc_hd__a2bb2o_1
XFILLER_32_432 VGND VGND VPWR VPWR sky130_fd_sc_hd__fill_2
XANTENNA__5078__S _5098_/S VGND VGND VPWR VPWR sky130_fd_sc_hd__diode_2
X_3841_ _6171_/Q _3902_/A2 _3840_/X VGND VGND VPWR VPWR _3841_/X sky130_fd_sc_hd__o21a_1
XFILLER_80_3 VPWR VGND VPWR VGND sky130_ef_sc_hd__decap_12
X_3772_ _3772_/A _3772_/B VGND VGND VPWR VPWR _3773_/B sky130_fd_sc_hd__and2_1
X_2723_ _6114_/Q VGND VGND VPWR VPWR _2803_/A sky130_fd_sc_hd__inv_2
X_5511_ _6050_/CLK _5511_/D fanout290/X VGND VGND VPWR VPWR _5511_/Q sky130_fd_sc_hd__dfrtp_1
X_5442_ _5442_/A _5442_/B VGND VGND VPWR VPWR _5442_/Y sky130_fd_sc_hd__xnor2_1
X_5373_ _5361_/X _5366_/B _5370_/Y _5372_/X _5410_/C VGND VGND VPWR VPWR _5373_/X
+ sky130_fd_sc_hd__o311a_1
X_4324_ _4152_/A _4150_/Y _4338_/B VGND VGND VPWR VPWR _4325_/B sky130_fd_sc_hd__a21bo_1
Xfanout106 _4878_/Y VGND VGND VPWR VPWR _4972_/A2 sky130_fd_sc_hd__clkbuf_2
Xfanout128 _4877_/X VGND VGND VPWR VPWR _4947_/B1 sky130_fd_sc_hd__clkbuf_2
Xfanout117 _5096_/S VGND VGND VPWR VPWR _5097_/S sky130_fd_sc_hd__clkbuf_4
X_4255_ _4320_/B _4320_/C _4255_/C VGND VGND VPWR VPWR _4310_/S sky130_fd_sc_hd__or3_4
Xfanout139 _5038_/A2 VGND VGND VPWR VPWR _4979_/A sky130_fd_sc_hd__clkbuf_4
X_3206_ _4970_/A0 _5732_/Q _3207_/S VGND VGND VPWR VPWR _5477_/D sky130_fd_sc_hd__mux2_1
X_4186_ _5904_/Q _5761_/Q _4241_/S VGND VGND VPWR VPWR _4186_/X sky130_fd_sc_hd__mux2_1
X_3137_ _5094_/A1 _2996_/Y _4682_/S _5469_/Q _3136_/X VGND VGND VPWR VPWR _3137_/Y
+ sky130_fd_sc_hd__a221oi_2
X_3068_ _5603_/Q _5652_/Q VGND VGND VPWR VPWR _3068_/X sky130_fd_sc_hd__or2_1
XANTENNA__5199__D _6171_/Q VGND VGND VPWR VPWR sky130_fd_sc_hd__diode_2
XFILLER_23_421 VGND VGND VPWR VPWR sky130_fd_sc_hd__fill_1
XFILLER_42_229 VGND VGND VPWR VPWR sky130_fd_sc_hd__fill_1
XFILLER_10_115 VGND VGND VPWR VPWR sky130_fd_sc_hd__decap_6
XANTENNA__2927__A2 _2895_/C VGND VGND VPWR VPWR sky130_fd_sc_hd__diode_2
X_5709_ _5723_/CLK _5709_/D fanout293/X VGND VGND VPWR VPWR _5709_/Q sky130_fd_sc_hd__dfrtp_1
Xhold160 _6069_/Q VGND VGND VPWR VPWR hold160/X sky130_fd_sc_hd__dlygate4sd3_1
Xhold171 _5896_/Q VGND VGND VPWR VPWR hold171/X sky130_fd_sc_hd__dlygate4sd3_1
Xhold193 _5773_/Q VGND VGND VPWR VPWR hold193/X sky130_fd_sc_hd__dlygate4sd3_1
Xhold182 _6092_/Q VGND VGND VPWR VPWR hold182/X sky130_fd_sc_hd__dlygate4sd3_1
XANTENNA__4604__A2 _4748_/A2 VGND VGND VPWR VPWR sky130_fd_sc_hd__diode_2
XFILLER_14_421 VPWR VGND VPWR VGND sky130_ef_sc_hd__decap_12
XTAP_TAPCELL_ROW_44_725 VGND VPWR sky130_fd_sc_hd__tapvpwrvgnd_1
XTAP_TAPCELL_ROW_44_736 VGND VPWR sky130_fd_sc_hd__tapvpwrvgnd_1
XTAP_TAPCELL_ROW_24_482 VGND VPWR sky130_fd_sc_hd__tapvpwrvgnd_1
XFILLER_6_697 VGND VGND VPWR VPWR sky130_fd_sc_hd__decap_3
XANTENNA__3670__A _4873_/A VGND VGND VPWR VPWR sky130_fd_sc_hd__diode_2
X_4040_ hold80/A hold95/A _4052_/S VGND VGND VPWR VPWR _4040_/X sky130_fd_sc_hd__mux2_1
XFILLER_37_513 VGND VGND VPWR VPWR sky130_fd_sc_hd__fill_2
XANTENNA__2854__A1 _6113_/Q VGND VGND VPWR VPWR sky130_fd_sc_hd__diode_2
X_5991_ _6131_/CLK _5991_/D fanout335/X VGND VGND VPWR VPWR _5991_/Q sky130_fd_sc_hd__dfrtp_1
X_4942_ hold383/X _4948_/A2 _4941_/X VGND VGND VPWR VPWR _5923_/D sky130_fd_sc_hd__a21o_1
XFILLER_17_281 VGND VGND VPWR VPWR sky130_fd_sc_hd__decap_8
XFILLER_17_292 VGND VGND VPWR VPWR sky130_fd_sc_hd__fill_2
X_4873_ _4873_/A _4873_/B _3725_/C VGND VGND VPWR VPWR _5186_/S sky130_fd_sc_hd__nor3b_2
X_3824_ _4100_/B _4100_/C _3773_/A VGND VGND VPWR VPWR _3824_/Y sky130_fd_sc_hd__a21oi_1
X_3755_ _5566_/Q _5567_/Q _5568_/Q VGND VGND VPWR VPWR _3785_/C sky130_fd_sc_hd__and3_1
X_3686_ _4399_/A _6051_/Q _3607_/D _3613_/Y _3615_/X VGND VGND VPWR VPWR _3716_/A
+ sky130_fd_sc_hd__a2111o_1
XANTENNA__3845__A _6171_/Q VGND VGND VPWR VPWR sky130_fd_sc_hd__diode_2
XTAP_TAPCELL_ROW_76_1126 VGND VPWR sky130_fd_sc_hd__tapvpwrvgnd_1
XANTENNA_fanout118_A _5096_/S VGND VGND VPWR VPWR sky130_fd_sc_hd__diode_2
XPHY_EDGE_ROW_12_Right_12 VGND VGND VPWR VPWR sky130_fd_sc_hd__decap_3
XANTENNA__3564__B _3564_/B VGND VGND VPWR VPWR sky130_fd_sc_hd__diode_2
X_5425_ _6171_/Q _5441_/B _5424_/Y VGND VGND VPWR VPWR _6171_/D sky130_fd_sc_hd__a21o_1
X_5356_ _5355_/X _5356_/B VGND VGND VPWR VPWR _5410_/C sky130_fd_sc_hd__and2b_2
X_4307_ _5573_/Q _5581_/Q _4307_/S VGND VGND VPWR VPWR _4307_/X sky130_fd_sc_hd__mux2_1
X_5287_ _5287_/A _5287_/B VGND VGND VPWR VPWR _5288_/B sky130_fd_sc_hd__or2_1
X_4238_ _5792_/Q _4167_/Y _4170_/Y _5784_/Q _4168_/Y VGND VGND VPWR VPWR _4238_/X
+ sky130_fd_sc_hd__a221o_1
X_4169_ _5901_/Q _4867_/B VGND VGND VPWR VPWR _4169_/X sky130_fd_sc_hd__or2_2
XFILLER_70_302 VGND VGND VPWR VPWR sky130_fd_sc_hd__fill_1
XPHY_EDGE_ROW_21_Right_21 VGND VGND VPWR VPWR sky130_fd_sc_hd__decap_3
XANTENNA__4598__A1 _4678_/A1 VGND VGND VPWR VPWR sky130_fd_sc_hd__diode_2
XTAP_TAPCELL_ROW_2_199 VGND VPWR sky130_fd_sc_hd__tapvpwrvgnd_1
XANTENNA__5011__A2 _5027_/A2 VGND VGND VPWR VPWR sky130_fd_sc_hd__diode_2
XFILLER_11_446 VGND VGND VPWR VPWR sky130_fd_sc_hd__fill_2
XTAP_TAPCELL_ROW_21_441 VGND VPWR sky130_fd_sc_hd__tapvpwrvgnd_1
XPHY_EDGE_ROW_30_Right_30 VGND VGND VPWR VPWR sky130_fd_sc_hd__decap_3
XFILLER_3_634 VPWR VGND VPWR VGND sky130_ef_sc_hd__decap_12
XFILLER_65_107 VGND VGND VPWR VPWR sky130_fd_sc_hd__decap_4
XFILLER_59_671 VGND VGND VPWR VPWR sky130_fd_sc_hd__fill_1
XANTENNA__2818__B _2964_/B VGND VGND VPWR VPWR sky130_fd_sc_hd__diode_2
XFILLER_0_69 VPWR VGND VPWR VGND sky130_ef_sc_hd__decap_12
XTAP_TAPCELL_ROW_29_541 VGND VPWR sky130_fd_sc_hd__tapvpwrvgnd_1
XANTENNA__4589__A1 _5763_/Q VGND VGND VPWR VPWR sky130_fd_sc_hd__diode_2
XTAP_TAPCELL_ROW_57_894 VGND VPWR sky130_fd_sc_hd__tapvpwrvgnd_1
XFILLER_64_83 VGND VGND VPWR VPWR sky130_fd_sc_hd__fill_1
XANTENNA__5002__A2 _5024_/A2 VGND VGND VPWR VPWR sky130_fd_sc_hd__diode_2
X_3540_ _3526_/X _3538_/Y _3539_/Y _3248_/B _4350_/A VGND VGND VPWR VPWR _3562_/D
+ sky130_fd_sc_hd__a2111o_1
XANTENNA__4761__B2 _3564_/A VGND VGND VPWR VPWR sky130_fd_sc_hd__diode_2
X_5210_ _5210_/A _5210_/B VGND VGND VPWR VPWR _5211_/B sky130_fd_sc_hd__nor2_1
X_3471_ _3565_/A _3488_/B VGND VGND VPWR VPWR _4350_/B sky130_fd_sc_hd__or2_1
XFILLER_43_3 VGND VGND VPWR VPWR sky130_fd_sc_hd__decap_6
X_5141_ hold169/X _5517_/Q _5166_/S VGND VGND VPWR VPWR _6063_/D sky130_fd_sc_hd__mux2_1
XTAP_TAPCELL_ROW_71_1067 VGND VPWR sky130_fd_sc_hd__tapvpwrvgnd_1
X_5072_ hold236/X _5521_/Q _5099_/S VGND VGND VPWR VPWR _5995_/D sky130_fd_sc_hd__mux2_1
X_4023_ hold462/X _4024_/C _4022_/Y VGND VGND VPWR VPWR _5653_/D sky130_fd_sc_hd__o21a_1
XFILLER_25_505 VGND VGND VPWR VPWR sky130_fd_sc_hd__decap_4
XANTENNA__2744__A _2744_/A VGND VGND VPWR VPWR sky130_fd_sc_hd__diode_2
XFILLER_25_527 VGND VGND VPWR VPWR sky130_fd_sc_hd__decap_8
X_5974_ clkload3/A _5974_/D fanout272/X VGND VGND VPWR VPWR _5974_/Q sky130_fd_sc_hd__dfrtp_1
X_4925_ _5494_/Q _4618_/X _4949_/S VGND VGND VPWR VPWR _4925_/X sky130_fd_sc_hd__mux2_1
X_4856_ _5474_/Q hold277/X _4864_/S VGND VGND VPWR VPWR _5890_/D sky130_fd_sc_hd__mux2_1
X_3807_ _5806_/Q _5507_/Q _3904_/S VGND VGND VPWR VPWR _3807_/X sky130_fd_sc_hd__mux2_1
XANTENNA_clkbuf_leaf_30_clk_A clkload2/A VGND VGND VPWR VPWR sky130_fd_sc_hd__diode_2
X_4787_ _5487_/Q hold314/X _4807_/S VGND VGND VPWR VPWR _5824_/D sky130_fd_sc_hd__mux2_1
XANTENNA__4752__A1 _4226_/S VGND VGND VPWR VPWR sky130_fd_sc_hd__diode_2
X_3738_ _4866_/S _5719_/Q _4109_/C _4865_/A _3737_/Y VGND VGND VPWR VPWR _3738_/X
+ sky130_fd_sc_hd__a41o_1
X_3669_ _6103_/Q _4464_/A VGND VGND VPWR VPWR _3710_/B sky130_fd_sc_hd__and2_1
XANTENNA_clkbuf_leaf_45_clk_A clkload1/A VGND VGND VPWR VPWR sky130_fd_sc_hd__diode_2
X_5408_ _5409_/A _5409_/B _5409_/C VGND VGND VPWR VPWR _5415_/B sky130_fd_sc_hd__o21a_1
X_5339_ _5329_/X _5331_/X _5338_/Y VGND VGND VPWR VPWR _5339_/X sky130_fd_sc_hd__o21a_1
XFILLER_0_615 VGND VGND VPWR VPWR sky130_fd_sc_hd__fill_1
XTAP_TAPCELL_ROW_7_269 VGND VPWR sky130_fd_sc_hd__tapvpwrvgnd_1
XFILLER_75_449 VGND VGND VPWR VPWR sky130_fd_sc_hd__fill_1
XFILLER_55_151 VGND VGND VPWR VPWR sky130_fd_sc_hd__decap_3
XFILLER_28_365 VPWR VGND VPWR VGND sky130_ef_sc_hd__decap_12
XTAP_TAPCELL_ROW_26_500 VGND VPWR sky130_fd_sc_hd__tapvpwrvgnd_1
XTAP_TAPCELL_ROW_26_511 VGND VPWR sky130_fd_sc_hd__tapvpwrvgnd_1
XTAP_TAPCELL_ROW_54_853 VGND VPWR sky130_fd_sc_hd__tapvpwrvgnd_1
XFILLER_24_560 VGND VGND VPWR VPWR sky130_fd_sc_hd__fill_1
XANTENNA__2804__D _2871_/B VGND VGND VPWR VPWR sky130_fd_sc_hd__diode_2
XFILLER_7_225 VGND VGND VPWR VPWR sky130_fd_sc_hd__decap_4
XANTENNA__5473__Q _5473_/Q VGND VGND VPWR VPWR sky130_fd_sc_hd__diode_2
XFILLER_3_442 VGND VGND VPWR VPWR sky130_fd_sc_hd__decap_6
XFILLER_62_600 VGND VGND VPWR VPWR sky130_fd_sc_hd__fill_1
XFILLER_61_110 VGND VGND VPWR VPWR sky130_fd_sc_hd__fill_2
XFILLER_19_387 VGND VGND VPWR VPWR sky130_fd_sc_hd__decap_4
XFILLER_34_302 VGND VGND VPWR VPWR sky130_fd_sc_hd__decap_6
XFILLER_34_313 VGND VGND VPWR VPWR sky130_fd_sc_hd__fill_1
XFILLER_62_699 VGND VGND VPWR VPWR sky130_fd_sc_hd__fill_1
X_2971_ _2980_/A _3129_/B _2977_/A VGND VGND VPWR VPWR _2971_/X sky130_fd_sc_hd__and3b_2
X_4710_ _4750_/A1 _4709_/X _4750_/C1 VGND VGND VPWR VPWR _4710_/X sky130_fd_sc_hd__o21a_1
X_5690_ _5690_/CLK _5690_/D fanout317/X VGND VGND VPWR VPWR hold98/A sky130_fd_sc_hd__dfrtp_1
XFILLER_30_530 VGND VGND VPWR VPWR sky130_fd_sc_hd__fill_2
X_4641_ hold320/X _4737_/A2 _4640_/X VGND VGND VPWR VPWR _5778_/D sky130_fd_sc_hd__o21a_1
XANTENNA__5086__S _5098_/S VGND VGND VPWR VPWR sky130_fd_sc_hd__diode_2
XANTENNA__4734__A1 _4750_/A1 VGND VGND VPWR VPWR sky130_fd_sc_hd__diode_2
X_4572_ _5945_/Q _4166_/C _4684_/B1 _4571_/X VGND VGND VPWR VPWR _4572_/X sky130_fd_sc_hd__a211o_1
Xfanout8 _5250_/Y VGND VGND VPWR VPWR _5327_/C sky130_fd_sc_hd__buf_2
X_3523_ _3538_/A _3523_/B _3523_/C VGND VGND VPWR VPWR _3523_/Y sky130_fd_sc_hd__nand3_2
X_3454_ _3705_/A _3530_/A _3454_/C _3454_/D VGND VGND VPWR VPWR _3918_/B sky130_fd_sc_hd__or4_1
XANTENNA__3842__B _3913_/B VGND VGND VPWR VPWR sky130_fd_sc_hd__diode_2
XANTENNA__3170__B1 _3138_/B VGND VGND VPWR VPWR sky130_fd_sc_hd__diode_2
X_3385_ hold146/X _3396_/A _4544_/A _3384_/X VGND VGND VPWR VPWR _5510_/D sky130_fd_sc_hd__a22o_1
X_6173_ clkload7/A _6173_/D fanout286/X VGND VGND VPWR VPWR _6173_/Q sky130_fd_sc_hd__dfrtp_1
XANTENNA__2739__A _4943_/S VGND VGND VPWR VPWR sky130_fd_sc_hd__diode_2
XTAP_TAPCELL_ROW_4_228 VGND VPWR sky130_fd_sc_hd__tapvpwrvgnd_1
X_5124_ _3128_/B _5189_/A2 _5863_/D _6162_/Q VGND VGND VPWR VPWR _6047_/D sky130_fd_sc_hd__a22o_1
Xclkbuf_leaf_49_clk clkload0/A VGND VGND VPWR VPWR clkload8/A sky130_fd_sc_hd__clkbuf_8
X_5055_ _5979_/Q _5377_/A _5055_/S VGND VGND VPWR VPWR _5979_/D sky130_fd_sc_hd__mux2_1
XFILLER_72_419 VGND VGND VPWR VPWR sky130_fd_sc_hd__fill_1
X_4006_ hold9/A _5642_/Q _4006_/S VGND VGND VPWR VPWR _5642_/D sky130_fd_sc_hd__mux2_1
XANTENNA__2745__Y _4464_/A VGND VGND VPWR VPWR sky130_fd_sc_hd__diode_2
XFILLER_38_696 VGND VGND VPWR VPWR sky130_fd_sc_hd__decap_4
XANTENNA_fanout352_A input1/X VGND VGND VPWR VPWR sky130_fd_sc_hd__diode_2
XFILLER_53_655 VGND VGND VPWR VPWR sky130_fd_sc_hd__fill_1
XFILLER_25_335 VGND VGND VPWR VPWR sky130_fd_sc_hd__fill_1
XANTENNA__3225__A1 _5490_/Q VGND VGND VPWR VPWR sky130_fd_sc_hd__diode_2
X_5957_ _5965_/CLK _5957_/D fanout302/X VGND VGND VPWR VPWR _5957_/Q sky130_fd_sc_hd__dfrtp_1
XTAP_TAPCELL_ROW_51_823 VGND VPWR sky130_fd_sc_hd__tapvpwrvgnd_1
XTAP_TAPCELL_ROW_51_812 VGND VPWR sky130_fd_sc_hd__tapvpwrvgnd_1
XANTENNA_fanout140_X _5038_/A2 VGND VGND VPWR VPWR sky130_fd_sc_hd__diode_2
X_4908_ _4575_/X _4950_/A2 _4950_/B1 _4907_/X VGND VGND VPWR VPWR _4908_/X sky130_fd_sc_hd__a22o_1
X_5888_ _6092_/CLK _5888_/D fanout339/X VGND VGND VPWR VPWR _5888_/Q sky130_fd_sc_hd__dfrtp_1
X_4839_ _5523_/Q hold335/X _4863_/S VGND VGND VPWR VPWR _5873_/D sky130_fd_sc_hd__mux2_1
XFILLER_4_217 VPWR VGND VPWR VGND sky130_ef_sc_hd__decap_12
XANTENNA_fanout98_A _5172_/S VGND VGND VPWR VPWR sky130_fd_sc_hd__diode_2
XANTENNA__5150__A1 _5488_/Q VGND VGND VPWR VPWR sky130_fd_sc_hd__diode_2
XANTENNA__3161__B1 _3138_/B VGND VGND VPWR VPWR sky130_fd_sc_hd__diode_2
XFILLER_0_445 VGND VGND VPWR VPWR sky130_fd_sc_hd__decap_3
XTAP_TAPCELL_ROW_59_923 VGND VPWR sky130_fd_sc_hd__tapvpwrvgnd_1
XTAP_TAPCELL_ROW_59_912 VGND VPWR sky130_fd_sc_hd__tapvpwrvgnd_1
Xhold20 hold20/A VGND VGND VPWR VPWR hold20/X sky130_fd_sc_hd__dlygate4sd3_1
Xhold31 hold31/A VGND VGND VPWR VPWR hold31/X sky130_fd_sc_hd__dlygate4sd3_1
Xhold42 hold42/A VGND VGND VPWR VPWR hold42/X sky130_fd_sc_hd__dlygate4sd3_1
Xhold53 hold53/A VGND VGND VPWR VPWR hold53/X sky130_fd_sc_hd__dlygate4sd3_1
Xhold64 hold64/A VGND VGND VPWR VPWR hold64/X sky130_fd_sc_hd__dlygate4sd3_1
Xhold97 hold97/A VGND VGND VPWR VPWR hold97/X sky130_fd_sc_hd__dlygate4sd3_1
Xhold75 hold75/A VGND VGND VPWR VPWR hold75/X sky130_fd_sc_hd__dlygate4sd3_1
Xhold86 hold86/A VGND VGND VPWR VPWR hold86/X sky130_fd_sc_hd__dlygate4sd3_1
XANTENNA_fanout53_X _4678_/A1 VGND VGND VPWR VPWR sky130_fd_sc_hd__diode_2
XFILLER_16_357 VGND VGND VPWR VPWR sky130_fd_sc_hd__decap_6
XFILLER_28_195 VGND VGND VPWR VPWR sky130_fd_sc_hd__fill_1
XFILLER_45_41 VGND VGND VPWR VPWR sky130_fd_sc_hd__fill_1
XANTENNA__5468__Q _5468_/Q VGND VGND VPWR VPWR sky130_fd_sc_hd__diode_2
XFILLER_8_589 VGND VGND VPWR VPWR sky130_fd_sc_hd__fill_2
XANTENNA__5141__A1 _5517_/Q VGND VGND VPWR VPWR sky130_fd_sc_hd__diode_2
X_3170_ _2993_/X _3169_/X _3138_/B VGND VGND VPWR VPWR _3170_/X sky130_fd_sc_hd__a21o_1
XFILLER_54_419 VGND VGND VPWR VPWR sky130_fd_sc_hd__fill_1
XANTENNA__6148__RESET_B fanout310/X VGND VGND VPWR VPWR sky130_fd_sc_hd__diode_2
XANTENNA__4652__B1 _4684_/B1 VGND VGND VPWR VPWR sky130_fd_sc_hd__diode_2
XTAP_TAPCELL_ROW_37_639 VGND VPWR sky130_fd_sc_hd__tapvpwrvgnd_1
XFILLER_35_666 VGND VGND VPWR VPWR sky130_fd_sc_hd__decap_4
X_5811_ _5811_/CLK _5811_/D fanout288/X VGND VGND VPWR VPWR _5811_/Q sky130_fd_sc_hd__dfrtp_1
XTAP_TAPCELL_ROW_17_396 VGND VPWR sky130_fd_sc_hd__tapvpwrvgnd_1
X_5742_ clkload8/A _5742_/D fanout284/X VGND VGND VPWR VPWR _5742_/Q sky130_fd_sc_hd__dfrtp_1
XFILLER_34_187 VGND VGND VPWR VPWR sky130_fd_sc_hd__fill_2
X_2954_ _3208_/A _3956_/S _3208_/C _2954_/D VGND VGND VPWR VPWR _2954_/X sky130_fd_sc_hd__or4_1
X_2885_ _2895_/A _5885_/Q _2895_/C _2786_/X _5881_/Q VGND VGND VPWR VPWR _2889_/A
+ sky130_fd_sc_hd__a32o_1
X_5673_ _5690_/CLK hold11/X VGND VGND VPWR VPWR _5673_/Q sky130_fd_sc_hd__dfxtp_1
X_4624_ _4688_/B2 _4623_/X _4622_/X _4720_/C1 VGND VGND VPWR VPWR _4624_/X sky130_fd_sc_hd__a211o_1
XPHY_EDGE_ROW_6_Right_6 VGND VGND VPWR VPWR sky130_fd_sc_hd__decap_3
X_4555_ _5763_/Q _4761_/A2 _3548_/Y _5863_/D VGND VGND VPWR VPWR _5763_/D sky130_fd_sc_hd__a22o_1
X_3506_ _3508_/A _3538_/B VGND VGND VPWR VPWR _3506_/X sky130_fd_sc_hd__and2_1
XANTENNA__3391__B1 _4870_/A1 VGND VGND VPWR VPWR sky130_fd_sc_hd__diode_2
XANTENNA__3572__B _4517_/A VGND VGND VPWR VPWR sky130_fd_sc_hd__diode_2
X_4486_ _4496_/A _4495_/B _4485_/Y _4436_/S _4483_/Y VGND VGND VPWR VPWR _4486_/X
+ sky130_fd_sc_hd__a311o_1
X_3437_ hold31/X _5584_/Q _3442_/S VGND VGND VPWR VPWR _5551_/D sky130_fd_sc_hd__mux2_1
X_6156_ _6159_/CLK _6156_/D fanout282/X VGND VGND VPWR VPWR _6156_/Q sky130_fd_sc_hd__dfrtp_1
X_3368_ _4551_/B _3368_/B _3368_/C VGND VGND VPWR VPWR _3368_/X sky130_fd_sc_hd__and3_1
XFILLER_66_29 VGND VGND VPWR VPWR sky130_fd_sc_hd__decap_6
XANTENNA__3999__S _4005_/S VGND VGND VPWR VPWR sky130_fd_sc_hd__diode_2
X_5107_ hold419/X _5427_/A _5127_/B VGND VGND VPWR VPWR _6030_/D sky130_fd_sc_hd__mux2_1
X_6087_ _6091_/CLK _6087_/D fanout343/X VGND VGND VPWR VPWR _6087_/Q sky130_fd_sc_hd__dfrtp_1
X_3299_ _3343_/A _3345_/A _3362_/A VGND VGND VPWR VPWR _3299_/X sky130_fd_sc_hd__or3_1
XANTENNA_fanout188_X _5201_/B VGND VGND VPWR VPWR sky130_fd_sc_hd__diode_2
XANTENNA__2916__B _2916_/B VGND VGND VPWR VPWR sky130_fd_sc_hd__diode_2
X_5038_ _4733_/X _5038_/A2 _5038_/B1 _4967_/X VGND VGND VPWR VPWR _5038_/X sky130_fd_sc_hd__a22o_1
XANTENNA__4643__B1 _4684_/B1 VGND VGND VPWR VPWR sky130_fd_sc_hd__diode_2
XFILLER_25_121 VGND VGND VPWR VPWR sky130_fd_sc_hd__fill_1
XTAP_TAPCELL_ROW_64_981 VGND VPWR sky130_fd_sc_hd__tapvpwrvgnd_1
XFILLER_53_485 VGND VGND VPWR VPWR sky130_fd_sc_hd__decap_3
XFILLER_15_11 VGND VGND VPWR VPWR sky130_fd_sc_hd__fill_2
XFILLER_25_165 VGND VGND VPWR VPWR sky130_fd_sc_hd__decap_3
XFILLER_9_309 VGND VGND VPWR VPWR sky130_fd_sc_hd__decap_8
XFILLER_21_393 VGND VGND VPWR VPWR sky130_fd_sc_hd__fill_1
XANTENNA__3921__A2 _3240_/B VGND VGND VPWR VPWR sky130_fd_sc_hd__diode_2
XFILLER_0_253 VPWR VGND VPWR VGND sky130_ef_sc_hd__decap_12
XANTENNA__4634__A0 _5468_/Q VGND VGND VPWR VPWR sky130_fd_sc_hd__diode_2
XFILLER_32_614 VGND VGND VPWR VPWR sky130_fd_sc_hd__decap_6
XTAP_TAPCELL_ROW_34_609 VGND VPWR sky130_fd_sc_hd__tapvpwrvgnd_1
XFILLER_44_474 VGND VGND VPWR VPWR sky130_fd_sc_hd__fill_2
XFILLER_72_94 VGND VGND VPWR VPWR sky130_fd_sc_hd__decap_8
XTAP_TAPCELL_ROW_14_355 VGND VPWR sky130_fd_sc_hd__tapvpwrvgnd_1
XPHY_EDGE_ROW_59_Right_59 VGND VGND VPWR VPWR sky130_fd_sc_hd__decap_3
XFILLER_8_320 VGND VGND VPWR VPWR sky130_fd_sc_hd__decap_3
XFILLER_31_179 VPWR VGND VPWR VGND sky130_ef_sc_hd__decap_12
XFILLER_12_393 VPWR VGND VPWR VGND sky130_ef_sc_hd__decap_12
XANTENNA__3373__B1 _4544_/A VGND VGND VPWR VPWR sky130_fd_sc_hd__diode_2
X_4340_ _4340_/A _4340_/B _4340_/C VGND VGND VPWR VPWR _5734_/D sky130_fd_sc_hd__or3_1
X_4271_ _2767_/Y _4308_/A2 _4250_/Y _4270_/Y VGND VGND VPWR VPWR _4271_/X sky130_fd_sc_hd__a22o_1
XANTENNA__5114__A1 _4427_/A VGND VGND VPWR VPWR sky130_fd_sc_hd__diode_2
XFILLER_4_581 VGND VGND VPWR VPWR sky130_fd_sc_hd__decap_6
X_6010_ _6094_/CLK _6010_/D fanout350/X VGND VGND VPWR VPWR _6010_/Q sky130_fd_sc_hd__dfrtp_1
X_3222_ _2824_/C _5487_/Q _3229_/S VGND VGND VPWR VPWR _5487_/D sky130_fd_sc_hd__mux2_1
XPHY_EDGE_ROW_68_Right_68 VGND VGND VPWR VPWR sky130_fd_sc_hd__decap_3
X_3153_ _5948_/Q _3153_/B VGND VGND VPWR VPWR _3153_/X sky130_fd_sc_hd__or2_1
XFILLER_39_268 VPWR VGND VPWR VGND sky130_ef_sc_hd__decap_12
XTAP_TAPCELL_ROW_68_1028 VGND VPWR sky130_fd_sc_hd__tapvpwrvgnd_1
XANTENNA__4625__B1 _4624_/X VGND VGND VPWR VPWR sky130_fd_sc_hd__diode_2
XFILLER_54_205 VGND VGND VPWR VPWR sky130_fd_sc_hd__fill_1
X_3084_ _5592_/Q _5678_/Q VGND VGND VPWR VPWR _3086_/C sky130_fd_sc_hd__xor2_1
XFILLER_35_485 VGND VGND VPWR VPWR sky130_fd_sc_hd__decap_6
XPHY_EDGE_ROW_77_Right_77 VGND VGND VPWR VPWR sky130_fd_sc_hd__decap_3
XTAP_TAPCELL_ROW_61_940 VGND VPWR sky130_fd_sc_hd__tapvpwrvgnd_1
XANTENNA__5050__A0 _3626_/A VGND VGND VPWR VPWR sky130_fd_sc_hd__diode_2
X_3986_ _5643_/Q hold9/A _5633_/Q VGND VGND VPWR VPWR _3996_/A sky130_fd_sc_hd__or3b_1
XFILLER_22_135 VGND VGND VPWR VPWR sky130_fd_sc_hd__fill_1
X_5725_ _5788_/CLK _5725_/D fanout304/X VGND VGND VPWR VPWR _5725_/Q sky130_fd_sc_hd__dfrtp_4
X_2937_ _2937_/A _2937_/B VGND VGND VPWR VPWR _2937_/Y sky130_fd_sc_hd__nor2_1
XFILLER_50_477 VGND VGND VPWR VPWR sky130_fd_sc_hd__decap_6
X_5656_ _5685_/CLK _5656_/D fanout318/X VGND VGND VPWR VPWR _5656_/Q sky130_fd_sc_hd__dfrtp_1
X_4607_ _4686_/A1 _4605_/X _4604_/X _4678_/C1 VGND VGND VPWR VPWR _4607_/X sky130_fd_sc_hd__o211a_1
X_2868_ _2868_/A _2868_/B _2868_/C VGND VGND VPWR VPWR _2868_/X sky130_fd_sc_hd__or3_1
XTAP_TAPCELL_ROW_79_1168 VGND VPWR sky130_fd_sc_hd__tapvpwrvgnd_1
X_2799_ _5824_/Q _2916_/B _2918_/B1 _5836_/Q _2798_/X VGND VGND VPWR VPWR _2799_/X
+ sky130_fd_sc_hd__a221o_1
Xhold320 _5778_/Q VGND VGND VPWR VPWR hold320/X sky130_fd_sc_hd__dlygate4sd3_1
X_5587_ _5696_/CLK _5587_/D fanout322/X VGND VGND VPWR VPWR _5587_/Q sky130_fd_sc_hd__dfrtp_1
Xhold342 _5842_/Q VGND VGND VPWR VPWR hold342/X sky130_fd_sc_hd__dlygate4sd3_1
XANTENNA_fanout103_X _5027_/A2 VGND VGND VPWR VPWR sky130_fd_sc_hd__diode_2
Xhold331 _6045_/Q VGND VGND VPWR VPWR hold331/X sky130_fd_sc_hd__dlygate4sd3_1
X_4538_ _4536_/A _4475_/B _4537_/X VGND VGND VPWR VPWR _5750_/D sky130_fd_sc_hd__a21bo_1
Xhold353 _5978_/Q VGND VGND VPWR VPWR hold353/X sky130_fd_sc_hd__dlygate4sd3_1
Xhold386 _6150_/Q VGND VGND VPWR VPWR hold386/X sky130_fd_sc_hd__dlygate4sd3_1
X_4469_ _4485_/B _4469_/B VGND VGND VPWR VPWR _4469_/Y sky130_fd_sc_hd__nand2_1
Xhold375 _5683_/Q VGND VGND VPWR VPWR hold375/X sky130_fd_sc_hd__dlygate4sd3_1
XANTENNA__5105__A1 _5412_/A VGND VGND VPWR VPWR sky130_fd_sc_hd__diode_2
Xhold364 _5621_/Q VGND VGND VPWR VPWR hold364/X sky130_fd_sc_hd__dlygate4sd3_1
Xhold397 _5956_/Q VGND VGND VPWR VPWR hold397/X sky130_fd_sc_hd__dlygate4sd3_1
XANTENNA__4864__A0 _4973_/A0 VGND VGND VPWR VPWR sky130_fd_sc_hd__diode_2
X_6139_ _6163_/CLK _6139_/D fanout314/X VGND VGND VPWR VPWR hold51/A sky130_fd_sc_hd__dfrtp_1
XANTENNA__2890__A2 _2886_/B VGND VGND VPWR VPWR sky130_fd_sc_hd__diode_2
XFILLER_73_503 VGND VGND VPWR VPWR sky130_fd_sc_hd__fill_1
XFILLER_42_53 VGND VGND VPWR VPWR sky130_fd_sc_hd__decap_3
XTAP_TAPCELL_ROW_11_314 VGND VPWR sky130_fd_sc_hd__tapvpwrvgnd_1
XFILLER_22_691 VGND VGND VPWR VPWR sky130_fd_sc_hd__fill_1
XFILLER_5_356 VPWR VGND VPWR VGND sky130_ef_sc_hd__decap_12
XANTENNA__3579__A_N _4447_/B VGND VGND VPWR VPWR sky130_fd_sc_hd__diode_2
XANTENNA__4855__A0 _5473_/Q VGND VGND VPWR VPWR sky130_fd_sc_hd__diode_2
XANTENNA__3930__D_N _6128_/D VGND VGND VPWR VPWR sky130_fd_sc_hd__diode_2
XANTENNA__3432__S _3434_/S VGND VGND VPWR VPWR sky130_fd_sc_hd__diode_2
XFILLER_37_706 VGND VGND VPWR VPWR sky130_fd_sc_hd__decap_6
XTAP_TAPCELL_ROW_19_414 VGND VPWR sky130_fd_sc_hd__tapvpwrvgnd_1
XFILLER_36_249 VGND VGND VPWR VPWR sky130_fd_sc_hd__decap_3
XTAP_TAPCELL_ROW_47_767 VGND VPWR sky130_fd_sc_hd__tapvpwrvgnd_1
X_3840_ _3623_/A _4762_/C _3839_/X _3845_/B VGND VGND VPWR VPWR _3840_/X sky130_fd_sc_hd__a211o_1
XANTENNA__5032__B1 _5038_/B1 VGND VGND VPWR VPWR sky130_fd_sc_hd__diode_2
X_3771_ _3906_/A1 _3906_/A2 _3769_/X _3770_/X VGND VGND VPWR VPWR _3772_/B sky130_fd_sc_hd__a31oi_1
X_2722_ _5751_/Q VGND VGND VPWR VPWR _2722_/Y sky130_fd_sc_hd__inv_2
X_5510_ _6026_/CLK _5510_/D fanout278/X VGND VGND VPWR VPWR _5510_/Q sky130_fd_sc_hd__dfrtp_1
XFILLER_73_3 VPWR VGND VPWR VGND sky130_ef_sc_hd__decap_12
XANTENNA__5094__S _5098_/S VGND VGND VPWR VPWR sky130_fd_sc_hd__diode_2
X_5441_ _6174_/Q _5441_/B VGND VGND VPWR VPWR _5441_/Y sky130_fd_sc_hd__nand2_1
X_5372_ _5372_/A _5372_/B _5372_/C VGND VGND VPWR VPWR _5372_/X sky130_fd_sc_hd__or3_1
X_4323_ _5722_/Q _5721_/Q _5723_/Q VGND VGND VPWR VPWR _4323_/Y sky130_fd_sc_hd__nor3_1
Xfanout107 _4878_/Y VGND VGND VPWR VPWR _4951_/A2 sky130_fd_sc_hd__clkbuf_4
Xfanout118 _5096_/S VGND VGND VPWR VPWR _5098_/S sky130_fd_sc_hd__clkbuf_4
Xfanout129 _4809_/S VGND VGND VPWR VPWR _4805_/S sky130_fd_sc_hd__clkbuf_4
X_4254_ _4320_/B _4320_/C _4255_/C VGND VGND VPWR VPWR _4254_/Y sky130_fd_sc_hd__nor3_1
XANTENNA__4846__A0 _5492_/Q VGND VGND VPWR VPWR sky130_fd_sc_hd__diode_2
X_3205_ _4967_/A0 _5731_/Q _3207_/S VGND VGND VPWR VPWR _5476_/D sky130_fd_sc_hd__mux2_1
X_4185_ _5770_/Q _4169_/X _4184_/X _3192_/B VGND VGND VPWR VPWR _4190_/A sky130_fd_sc_hd__o211a_1
XANTENNA__2747__A _3639_/A VGND VGND VPWR VPWR sky130_fd_sc_hd__diode_2
X_3136_ _5489_/Q _4610_/S _4879_/B _5519_/Q VGND VGND VPWR VPWR _3136_/X sky130_fd_sc_hd__a22o_1
X_3067_ _5603_/Q _5652_/Q VGND VGND VPWR VPWR _3067_/Y sky130_fd_sc_hd__nand2_1
XFILLER_23_433 VGND VGND VPWR VPWR sky130_fd_sc_hd__decap_3
XFILLER_23_444 VGND VGND VPWR VPWR sky130_fd_sc_hd__decap_4
X_5708_ _5723_/CLK _5708_/D fanout293/X VGND VGND VPWR VPWR _5708_/Q sky130_fd_sc_hd__dfrtp_1
XFILLER_10_138 VGND VGND VPWR VPWR sky130_fd_sc_hd__fill_2
X_3969_ _5599_/Q _3426_/D _3968_/X _4542_/A hold412/X VGND VGND VPWR VPWR _5616_/D
+ sky130_fd_sc_hd__a32o_1
XFILLER_12_78 VGND VGND VPWR VPWR sky130_fd_sc_hd__fill_1
XFILLER_12_67 VGND VGND VPWR VPWR sky130_fd_sc_hd__fill_1
XFILLER_12_56 VGND VGND VPWR VPWR sky130_fd_sc_hd__decap_6
X_5639_ _6149_/CLK _5639_/D VGND VGND VPWR VPWR _5639_/Q sky130_fd_sc_hd__dfxtp_1
XANTENNA__3888__A1 _4517_/A VGND VGND VPWR VPWR sky130_fd_sc_hd__diode_2
Xhold161 _5828_/Q VGND VGND VPWR VPWR hold161/X sky130_fd_sc_hd__dlygate4sd3_1
Xhold150 _5504_/Q VGND VGND VPWR VPWR hold150/X sky130_fd_sc_hd__dlygate4sd3_1
Xhold183 _5999_/Q VGND VGND VPWR VPWR hold183/X sky130_fd_sc_hd__dlygate4sd3_1
Xhold194 _5790_/Q VGND VGND VPWR VPWR hold194/X sky130_fd_sc_hd__dlygate4sd3_1
Xhold172 _5805_/Q VGND VGND VPWR VPWR hold172/X sky130_fd_sc_hd__dlygate4sd3_1
XANTENNA__4837__A0 _5521_/Q VGND VGND VPWR VPWR sky130_fd_sc_hd__diode_2
XFILLER_58_330 VGND VGND VPWR VPWR sky130_fd_sc_hd__fill_1
XFILLER_58_363 VGND VGND VPWR VPWR sky130_fd_sc_hd__fill_1
XFILLER_37_75 VGND VGND VPWR VPWR sky130_fd_sc_hd__fill_1
XTAP_TAPCELL_ROW_44_726 VGND VPWR sky130_fd_sc_hd__tapvpwrvgnd_1
XANTENNA__5014__B1 _5038_/B1 VGND VGND VPWR VPWR sky130_fd_sc_hd__diode_2
XFILLER_53_52 VGND VGND VPWR VPWR sky130_fd_sc_hd__decap_4
XFILLER_14_433 VGND VGND VPWR VPWR sky130_fd_sc_hd__fill_2
XANTENNA__5476__Q _5476_/Q VGND VGND VPWR VPWR sky130_fd_sc_hd__diode_2
XTAP_TAPCELL_ROW_24_483 VGND VPWR sky130_fd_sc_hd__tapvpwrvgnd_1
XANTENNA__2918__A3 _2783_/B VGND VGND VPWR VPWR sky130_fd_sc_hd__diode_2
XFILLER_6_643 VGND VGND VPWR VPWR sky130_fd_sc_hd__fill_1
XANTENNA__3427__S _3434_/S VGND VGND VPWR VPWR sky130_fd_sc_hd__diode_2
XFILLER_5_197 VGND VGND VPWR VPWR sky130_fd_sc_hd__fill_1
XFILLER_37_503 VGND VGND VPWR VPWR sky130_fd_sc_hd__fill_1
XFILLER_64_333 VGND VGND VPWR VPWR sky130_fd_sc_hd__fill_1
XFILLER_37_558 VGND VGND VPWR VPWR sky130_fd_sc_hd__fill_2
X_5990_ clkload5/A _5990_/D fanout280/X VGND VGND VPWR VPWR _5990_/Q sky130_fd_sc_hd__dfrtp_1
X_4941_ _4663_/X _4947_/A2 _4947_/B1 _4940_/X VGND VGND VPWR VPWR _4941_/X sky130_fd_sc_hd__a22o_1
XANTENNA__5089__S _5096_/S VGND VGND VPWR VPWR sky130_fd_sc_hd__diode_2
X_4872_ _3728_/X _4871_/X _4869_/X VGND VGND VPWR VPWR _5901_/D sky130_fd_sc_hd__a21o_1
X_3823_ _5573_/Q _3834_/C VGND VGND VPWR VPWR _3823_/X sky130_fd_sc_hd__or2_1
XFILLER_20_447 VGND VGND VPWR VPWR sky130_fd_sc_hd__fill_2
X_3754_ _4109_/C _4865_/A _3753_/X _3750_/X VGND VGND VPWR VPWR _4112_/B sky130_fd_sc_hd__a31o_1
X_3685_ _3718_/C _3679_/Y _3684_/X _3668_/X _3676_/X VGND VGND VPWR VPWR _3703_/A
+ sky130_fd_sc_hd__o32a_1
XTAP_TAPCELL_ROW_76_1127 VGND VPWR sky130_fd_sc_hd__tapvpwrvgnd_1
X_5424_ _5420_/X _5422_/Y _5423_/Y VGND VGND VPWR VPWR _5424_/Y sky130_fd_sc_hd__a21oi_1
X_5355_ _5376_/B _5376_/C VGND VGND VPWR VPWR _5355_/X sky130_fd_sc_hd__and2_1
X_4306_ _5716_/Q _4305_/X _4312_/S VGND VGND VPWR VPWR _5716_/D sky130_fd_sc_hd__mux2_1
X_5286_ _5286_/A _5286_/B VGND VGND VPWR VPWR _5289_/A sky130_fd_sc_hd__nor2_1
X_4237_ hold230/X _4236_/X _4246_/S VGND VGND VPWR VPWR _5708_/D sky130_fd_sc_hd__mux2_1
X_4168_ _5901_/Q _4867_/B VGND VGND VPWR VPWR _4168_/Y sky130_fd_sc_hd__nor2_2
XANTENNA_clkbuf_leaf_4_clk_A clkload0/A VGND VGND VPWR VPWR sky130_fd_sc_hd__diode_2
XFILLER_28_525 VGND VGND VPWR VPWR sky130_fd_sc_hd__decap_6
XANTENNA__3274__A_N _3905_/A VGND VGND VPWR VPWR sky130_fd_sc_hd__diode_2
XANTENNA_fanout268_X _4973_/A0 VGND VGND VPWR VPWR sky130_fd_sc_hd__diode_2
X_3119_ _2968_/X _3116_/X _3117_/X _3118_/X _2981_/X VGND VGND VPWR VPWR _3119_/X
+ sky130_fd_sc_hd__o311a_1
XANTENNA_fanout170_X _3396_/A VGND VGND VPWR VPWR sky130_fd_sc_hd__diode_2
XFILLER_16_709 VGND VGND VPWR VPWR sky130_fd_sc_hd__decap_4
X_4099_ _4100_/B _4100_/C _5573_/Q VGND VGND VPWR VPWR _4119_/A sky130_fd_sc_hd__a21oi_1
XFILLER_70_369 VGND VGND VPWR VPWR sky130_fd_sc_hd__decap_4
XFILLER_23_296 VGND VGND VPWR VPWR sky130_fd_sc_hd__fill_1
XTAP_TAPCELL_ROW_21_442 VGND VPWR sky130_fd_sc_hd__tapvpwrvgnd_1
XFILLER_3_646 VPWR VGND VPWR VGND sky130_ef_sc_hd__decap_12
XFILLER_3_3 VPWR VGND VPWR VGND sky130_ef_sc_hd__decap_12
XFILLER_0_15 VPWR VGND VPWR VGND sky130_ef_sc_hd__decap_12
XFILLER_19_536 VGND VGND VPWR VPWR sky130_fd_sc_hd__decap_4
XFILLER_46_311 VGND VGND VPWR VPWR sky130_fd_sc_hd__fill_1
XANTENNA__4806__S _4810_/S VGND VGND VPWR VPWR sky130_fd_sc_hd__diode_2
XFILLER_73_130 VPWR VGND VPWR VGND sky130_ef_sc_hd__decap_12
XTAP_TAPCELL_ROW_29_542 VGND VPWR sky130_fd_sc_hd__tapvpwrvgnd_1
XTAP_TAPCELL_ROW_57_895 VGND VPWR sky130_fd_sc_hd__tapvpwrvgnd_1
XFILLER_14_263 VPWR VGND VPWR VGND sky130_ef_sc_hd__decap_12
XFILLER_80_94 VGND VGND VPWR VPWR sky130_fd_sc_hd__decap_3
XFILLER_6_440 VPWR VGND VPWR VGND sky130_ef_sc_hd__decap_12
X_3470_ _3470_/A _3470_/B VGND VGND VPWR VPWR _3488_/B sky130_fd_sc_hd__or2_1
XFILLER_36_3 VPWR VGND VPWR VGND sky130_ef_sc_hd__decap_12
X_5140_ _5759_/Q _5758_/Q _5140_/C VGND VGND VPWR VPWR _5140_/Y sky130_fd_sc_hd__nor3_1
XTAP_TAPCELL_ROW_71_1068 VGND VPWR sky130_fd_sc_hd__tapvpwrvgnd_1
XFILLER_69_447 VGND VGND VPWR VPWR sky130_fd_sc_hd__fill_1
X_5071_ hold138/X _5520_/Q _5097_/S VGND VGND VPWR VPWR _5994_/D sky130_fd_sc_hd__mux2_1
XANTENNA__3297__A_N _5406_/A VGND VGND VPWR VPWR sky130_fd_sc_hd__diode_2
X_4022_ hold11/A _4022_/B VGND VGND VPWR VPWR _4022_/Y sky130_fd_sc_hd__nor2_1
XFILLER_65_653 VGND VGND VPWR VPWR sky130_fd_sc_hd__fill_1
XFILLER_64_141 VGND VGND VPWR VPWR sky130_fd_sc_hd__decap_6
XANTENNA__3399__Y _3407_/S VGND VGND VPWR VPWR sky130_fd_sc_hd__diode_2
X_5973_ clkload3/A _5973_/D fanout272/X VGND VGND VPWR VPWR _5973_/Q sky130_fd_sc_hd__dfrtp_1
XFILLER_18_580 VGND VGND VPWR VPWR sky130_fd_sc_hd__fill_1
X_4924_ hold456/X _4951_/A2 _4923_/X VGND VGND VPWR VPWR _5917_/D sky130_fd_sc_hd__a21o_1
XFILLER_80_689 VGND VGND VPWR VPWR sky130_fd_sc_hd__fill_1
XFILLER_21_712 VGND VGND VPWR VPWR sky130_fd_sc_hd__fill_1
X_4855_ _5473_/Q hold283/X _4855_/S VGND VGND VPWR VPWR _5889_/D sky130_fd_sc_hd__mux2_1
X_4786_ _5524_/Q hold244/X _4807_/S VGND VGND VPWR VPWR _5823_/D sky130_fd_sc_hd__mux2_1
XANTENNA_fanout130_A _4810_/S VGND VGND VPWR VPWR sky130_fd_sc_hd__diode_2
XFILLER_20_266 VGND VGND VPWR VPWR sky130_fd_sc_hd__fill_1
X_3806_ _3378_/X _3767_/A _3804_/X _3783_/A VGND VGND VPWR VPWR _3810_/A sky130_fd_sc_hd__a22oi_2
X_3737_ _5566_/Q _3916_/S VGND VGND VPWR VPWR _3737_/Y sky130_fd_sc_hd__nor2_1
X_3668_ _3708_/C _3707_/A _3707_/B _3707_/C VGND VGND VPWR VPWR _3668_/X sky130_fd_sc_hd__or4_1
X_3599_ _6052_/Q _4424_/A VGND VGND VPWR VPWR _3713_/A sky130_fd_sc_hd__and2b_1
X_5407_ _5415_/A _5407_/B VGND VGND VPWR VPWR _5409_/C sky130_fd_sc_hd__nor2_1
X_5338_ _5338_/A _5338_/B VGND VGND VPWR VPWR _5338_/Y sky130_fd_sc_hd__nor2_1
XFILLER_48_609 VGND VGND VPWR VPWR sky130_fd_sc_hd__fill_1
X_5269_ _5262_/B _5264_/B _5260_/X VGND VGND VPWR VPWR _5270_/B sky130_fd_sc_hd__a21o_1
XANTENNA__4626__S _4674_/S VGND VGND VPWR VPWR sky130_fd_sc_hd__diode_2
XANTENNA__2935__A _5470_/Q VGND VGND VPWR VPWR sky130_fd_sc_hd__diode_2
XTAP_TAPCELL_ROW_26_501 VGND VPWR sky130_fd_sc_hd__tapvpwrvgnd_1
XFILLER_28_377 VPWR VGND VPWR VGND sky130_ef_sc_hd__decap_12
XTAP_TAPCELL_ROW_54_854 VGND VPWR sky130_fd_sc_hd__tapvpwrvgnd_1
XANTENNA__4991__A2 _5043_/A2 VGND VGND VPWR VPWR sky130_fd_sc_hd__diode_2
XANTENNA__4728__C1 _3877_/S VGND VGND VPWR VPWR sky130_fd_sc_hd__diode_2
XANTENNA__3766__A _3877_/S VGND VGND VPWR VPWR sky130_fd_sc_hd__diode_2
XFILLER_50_42 VPWR VGND VPWR VGND sky130_ef_sc_hd__decap_12
XANTENNA__5754__Q _5754_/Q VGND VGND VPWR VPWR sky130_fd_sc_hd__diode_2
XFILLER_66_439 VGND VGND VPWR VPWR sky130_fd_sc_hd__fill_1
Xfanout290 fanout292/X VGND VGND VPWR VPWR fanout290/X sky130_fd_sc_hd__clkbuf_4
XFILLER_47_664 VGND VGND VPWR VPWR sky130_fd_sc_hd__fill_1
XFILLER_19_366 VPWR VGND VPWR VGND sky130_ef_sc_hd__decap_12
XANTENNA__3440__S _3442_/S VGND VGND VPWR VPWR sky130_fd_sc_hd__diode_2
X_2970_ _2980_/A _3129_/B VGND VGND VPWR VPWR _2970_/X sky130_fd_sc_hd__and2b_1
XANTENNA__4982__A2 _5038_/A2 VGND VGND VPWR VPWR sky130_fd_sc_hd__diode_2
XFILLER_15_583 VGND VGND VPWR VPWR sky130_fd_sc_hd__decap_6
X_4640_ _4672_/A1 _4639_/X _4638_/X _4704_/C1 VGND VGND VPWR VPWR _4640_/X sky130_fd_sc_hd__a211o_1
XFILLER_30_586 VGND VGND VPWR VPWR sky130_fd_sc_hd__fill_2
X_4571_ _5912_/Q _5055_/S _4667_/B1 _4570_/X VGND VGND VPWR VPWR _4571_/X sky130_fd_sc_hd__a22o_1
XFILLER_6_270 VGND VGND VPWR VPWR sky130_fd_sc_hd__decap_6
Xfanout9 _5250_/Y VGND VGND VPWR VPWR fanout9/X sky130_fd_sc_hd__clkbuf_2
X_3522_ _3550_/B _3521_/Y _3519_/X VGND VGND VPWR VPWR _3522_/X sky130_fd_sc_hd__a21bo_1
XANTENNA__5989__RESET_B fanout286/X VGND VGND VPWR VPWR sky130_fd_sc_hd__diode_2
X_3453_ _3705_/A _3530_/A _3454_/C _3472_/A VGND VGND VPWR VPWR _5197_/A sky130_fd_sc_hd__or4_2
X_6172_ clkload7/A _6172_/D fanout285/X VGND VGND VPWR VPWR _6172_/Q sky130_fd_sc_hd__dfrtp_1
X_3384_ _5985_/Q _6029_/Q _3749_/A VGND VGND VPWR VPWR _3384_/X sky130_fd_sc_hd__mux2_1
X_5123_ _5123_/A _5123_/B VGND VGND VPWR VPWR _6046_/D sky130_fd_sc_hd__or2_1
XTAP_TAPCELL_ROW_4_229 VGND VPWR sky130_fd_sc_hd__tapvpwrvgnd_1
X_5054_ _4536_/A hold353/X _5054_/S VGND VGND VPWR VPWR _5978_/D sky130_fd_sc_hd__mux2_1
X_4005_ _5641_/Q _5642_/Q _4005_/S VGND VGND VPWR VPWR _5641_/D sky130_fd_sc_hd__mux2_1
XANTENNA__2755__A _6174_/Q VGND VGND VPWR VPWR sky130_fd_sc_hd__diode_2
XANTENNA__4670__A1 _4750_/A1 VGND VGND VPWR VPWR sky130_fd_sc_hd__diode_2
X_5956_ _5963_/CLK _5956_/D fanout308/X VGND VGND VPWR VPWR _5956_/Q sky130_fd_sc_hd__dfrtp_1
XTAP_TAPCELL_ROW_51_813 VGND VPWR sky130_fd_sc_hd__tapvpwrvgnd_1
X_5887_ _6092_/CLK _5887_/D fanout343/X VGND VGND VPWR VPWR _5887_/Q sky130_fd_sc_hd__dfrtp_1
X_4907_ _5488_/Q _4570_/X _4943_/S VGND VGND VPWR VPWR _4907_/X sky130_fd_sc_hd__mux2_1
X_4838_ _5522_/Q hold269/X _4862_/S VGND VGND VPWR VPWR _5872_/D sky130_fd_sc_hd__mux2_1
XTAP_TAPCELL_ROW_31_570 VGND VPWR sky130_fd_sc_hd__tapvpwrvgnd_1
XANTENNA__3462__A_N _6128_/D VGND VGND VPWR VPWR sky130_fd_sc_hd__diode_2
X_4769_ hold106/X _3817_/X _4776_/S VGND VGND VPWR VPWR _5807_/D sky130_fd_sc_hd__mux2_1
XFILLER_4_229 VGND VGND VPWR VPWR sky130_fd_sc_hd__decap_8
XTAP_TAPCELL_ROW_59_913 VGND VPWR sky130_fd_sc_hd__tapvpwrvgnd_1
Xhold32 hold32/A VGND VGND VPWR VPWR hold32/X sky130_fd_sc_hd__dlygate4sd3_1
XFILLER_29_21 VGND VGND VPWR VPWR sky130_fd_sc_hd__fill_1
Xhold21 hold21/A VGND VGND VPWR VPWR hold21/X sky130_fd_sc_hd__dlygate4sd3_1
Xhold10 hold10/A VGND VGND VPWR VPWR hold10/X sky130_fd_sc_hd__dlygate4sd3_1
Xhold43 hold43/A VGND VGND VPWR VPWR hold43/X sky130_fd_sc_hd__dlygate4sd3_1
XFILLER_29_65 VGND VGND VPWR VPWR sky130_fd_sc_hd__fill_2
Xhold65 hold65/A VGND VGND VPWR VPWR hold65/X sky130_fd_sc_hd__dlygate4sd3_1
Xhold54 hold54/A VGND VGND VPWR VPWR hold54/X sky130_fd_sc_hd__dlygate4sd3_1
Xhold98 hold98/A VGND VGND VPWR VPWR hold98/X sky130_fd_sc_hd__dlygate4sd3_1
XFILLER_28_141 VGND VGND VPWR VPWR sky130_fd_sc_hd__decap_3
Xhold76 hold76/A VGND VGND VPWR VPWR hold76/X sky130_fd_sc_hd__dlygate4sd3_1
Xhold87 hold87/A VGND VGND VPWR VPWR hold87/X sky130_fd_sc_hd__dlygate4sd3_1
XANTENNA__4661__A1 _5764_/Q VGND VGND VPWR VPWR sky130_fd_sc_hd__diode_2
XTAP_TAPCELL_ROW_39_670 VGND VPWR sky130_fd_sc_hd__tapvpwrvgnd_1
XANTENNA_fanout46_X _4740_/B1 VGND VGND VPWR VPWR sky130_fd_sc_hd__diode_2
XFILLER_16_325 VPWR VGND VPWR VGND sky130_ef_sc_hd__decap_12
XFILLER_43_122 VGND VGND VPWR VPWR sky130_fd_sc_hd__fill_1
XFILLER_71_486 VGND VGND VPWR VPWR sky130_fd_sc_hd__fill_1
XFILLER_45_97 VGND VGND VPWR VPWR sky130_fd_sc_hd__fill_1
XFILLER_61_52 VGND VGND VPWR VPWR sky130_fd_sc_hd__decap_4
XFILLER_12_597 VGND VGND VPWR VPWR sky130_fd_sc_hd__decap_3
XANTENNA__4716__A2 _4748_/A2 VGND VGND VPWR VPWR sky130_fd_sc_hd__diode_2
XANTENNA__3924__B1 _3541_/Y VGND VGND VPWR VPWR sky130_fd_sc_hd__diode_2
XANTENNA__3435__S _3442_/S VGND VGND VPWR VPWR sky130_fd_sc_hd__diode_2
XFILLER_19_174 VGND VGND VPWR VPWR sky130_fd_sc_hd__fill_1
XFILLER_47_494 VGND VGND VPWR VPWR sky130_fd_sc_hd__fill_1
XFILLER_62_475 VGND VGND VPWR VPWR sky130_fd_sc_hd__fill_1
XANTENNA_clkbuf_leaf_44_clk_A clkload1/A VGND VGND VPWR VPWR sky130_fd_sc_hd__diode_2
X_5810_ _6050_/CLK _5810_/D fanout290/X VGND VGND VPWR VPWR _5810_/Q sky130_fd_sc_hd__dfrtp_1
X_2953_ _5599_/Q _5611_/Q _5590_/Q VGND VGND VPWR VPWR _2954_/D sky130_fd_sc_hd__or3b_1
XTAP_TAPCELL_ROW_17_397 VGND VPWR sky130_fd_sc_hd__tapvpwrvgnd_1
X_5741_ clkload8/A _5741_/D fanout284/X VGND VGND VPWR VPWR _5741_/Q sky130_fd_sc_hd__dfrtp_1
XANTENNA__6117__RESET_B fanout313/X VGND VGND VPWR VPWR sky130_fd_sc_hd__diode_2
XANTENNA__5097__S _5097_/S VGND VGND VPWR VPWR sky130_fd_sc_hd__diode_2
XFILLER_15_391 VGND VGND VPWR VPWR sky130_fd_sc_hd__fill_1
X_2884_ _6065_/Q _5869_/Q _5993_/Q _5818_/Q _6114_/Q _6115_/Q VGND VGND VPWR VPWR
+ _2884_/X sky130_fd_sc_hd__mux4_1
X_5672_ _5685_/CLK _5672_/D VGND VGND VPWR VPWR hold11/A sky130_fd_sc_hd__dfxtp_2
XFILLER_30_383 VGND VGND VPWR VPWR sky130_fd_sc_hd__decap_4
X_4623_ _5918_/Q _5767_/Q _4623_/S VGND VGND VPWR VPWR _4623_/X sky130_fd_sc_hd__mux2_1
XANTENNA__4707__A2 _5066_/S VGND VGND VPWR VPWR sky130_fd_sc_hd__diode_2
X_4554_ _5762_/Q _5174_/A2 _3559_/Y _5863_/D VGND VGND VPWR VPWR _5762_/D sky130_fd_sc_hd__a22o_1
X_3505_ _3505_/A VGND VGND VPWR VPWR _3528_/B sky130_fd_sc_hd__inv_2
X_4485_ _4487_/B _4485_/B VGND VGND VPWR VPWR _4485_/Y sky130_fd_sc_hd__nand2_1
X_3436_ hold60/X _5583_/Q _3442_/S VGND VGND VPWR VPWR _5550_/D sky130_fd_sc_hd__mux2_1
XANTENNA_fanout295_A fanout298/X VGND VGND VPWR VPWR sky130_fd_sc_hd__diode_2
X_6155_ _6159_/CLK _6155_/D fanout282/X VGND VGND VPWR VPWR _6155_/Q sky130_fd_sc_hd__dfrtp_1
X_3367_ _3367_/A _3367_/B _3367_/C VGND VGND VPWR VPWR _3368_/C sky130_fd_sc_hd__or3_1
X_6086_ _6094_/CLK _6086_/D fanout350/X VGND VGND VPWR VPWR _6086_/Q sky130_fd_sc_hd__dfrtp_1
X_5106_ hold411/X _6171_/Q _5109_/S VGND VGND VPWR VPWR _6029_/D sky130_fd_sc_hd__mux2_1
X_5037_ _5964_/Q _5041_/A2 _5036_/X VGND VGND VPWR VPWR _5964_/D sky130_fd_sc_hd__a21o_1
X_3298_ _3298_/A _5985_/Q VGND VGND VPWR VPWR _3362_/A sky130_fd_sc_hd__nor2_1
XANTENNA__4643__A1 _4667_/B1 VGND VGND VPWR VPWR sky130_fd_sc_hd__diode_2
XFILLER_26_645 VGND VGND VPWR VPWR sky130_fd_sc_hd__decap_4
XANTENNA_fanout250_X _4404_/A VGND VGND VPWR VPWR sky130_fd_sc_hd__diode_2
XFILLER_80_272 VGND VGND VPWR VPWR sky130_fd_sc_hd__fill_1
XTAP_TAPCELL_ROW_64_982 VGND VPWR sky130_fd_sc_hd__tapvpwrvgnd_1
X_5939_ _5967_/CLK _5939_/D fanout307/X VGND VGND VPWR VPWR _5939_/Q sky130_fd_sc_hd__dfrtp_1
XFILLER_21_372 VGND VGND VPWR VPWR sky130_fd_sc_hd__fill_1
XFILLER_31_55 VGND VGND VPWR VPWR sky130_fd_sc_hd__fill_1
XFILLER_0_265 VPWR VGND VPWR VGND sky130_ef_sc_hd__decap_12
XFILLER_29_461 VGND VGND VPWR VPWR sky130_fd_sc_hd__decap_4
XFILLER_29_472 VPWR VGND VPWR VGND sky130_ef_sc_hd__decap_12
XFILLER_56_85 VPWR VGND VPWR VGND sky130_ef_sc_hd__decap_12
XFILLER_44_464 VGND VGND VPWR VPWR sky130_fd_sc_hd__decap_8
XFILLER_71_261 VGND VGND VPWR VPWR sky130_fd_sc_hd__fill_1
XTAP_TAPCELL_ROW_14_356 VGND VPWR sky130_fd_sc_hd__tapvpwrvgnd_1
XFILLER_8_354 VGND VGND VPWR VPWR sky130_fd_sc_hd__decap_8
XFILLER_8_365 VPWR VGND VPWR VGND sky130_ef_sc_hd__decap_12
XANTENNA__4570__A0 _5488_/Q VGND VGND VPWR VPWR sky130_fd_sc_hd__diode_2
X_4270_ _4270_/A VGND VGND VPWR VPWR _4270_/Y sky130_fd_sc_hd__inv_2
X_3221_ _5899_/Q _3399_/C _5900_/Q VGND VGND VPWR VPWR _3229_/S sky130_fd_sc_hd__nand3b_4
X_3152_ _6140_/Q _2965_/X _3147_/X _3151_/X VGND VGND VPWR VPWR _6140_/D sky130_fd_sc_hd__o22a_1
XFILLER_39_225 VGND VGND VPWR VPWR sky130_fd_sc_hd__fill_1
XFILLER_67_567 VGND VGND VPWR VPWR sky130_fd_sc_hd__fill_1
XTAP_TAPCELL_ROW_68_1029 VGND VPWR sky130_fd_sc_hd__tapvpwrvgnd_1
X_3083_ _5595_/Q _5681_/Q VGND VGND VPWR VPWR _3086_/B sky130_fd_sc_hd__xor2_1
XFILLER_35_431 VPWR VGND VPWR VGND sky130_ef_sc_hd__decap_12
XFILLER_23_615 VGND VGND VPWR VPWR sky130_fd_sc_hd__fill_1
XTAP_TAPCELL_ROW_61_941 VGND VPWR sky130_fd_sc_hd__tapvpwrvgnd_1
X_3985_ _5659_/Q _5643_/Q VGND VGND VPWR VPWR _4006_/S sky130_fd_sc_hd__nand2_1
X_5724_ _3182_/A1 _5724_/D fanout295/X VGND VGND VPWR VPWR _5724_/Q sky130_fd_sc_hd__dfstp_1
X_2936_ _5474_/Q _2823_/Y _2827_/Y _4973_/A0 _2934_/X VGND VGND VPWR VPWR _2936_/X
+ sky130_fd_sc_hd__o221a_1
XFILLER_10_309 VGND VGND VPWR VPWR sky130_fd_sc_hd__fill_2
X_2867_ _6008_/Q _2783_/B _2910_/B _6004_/Q _2864_/X VGND VGND VPWR VPWR _2868_/C
+ sky130_fd_sc_hd__a221o_1
X_5655_ _5685_/CLK _5655_/D fanout318/X VGND VGND VPWR VPWR _5655_/Q sky130_fd_sc_hd__dfrtp_1
X_4606_ _5916_/Q _5765_/Q _4623_/S VGND VGND VPWR VPWR _4606_/X sky130_fd_sc_hd__mux2_1
XTAP_TAPCELL_ROW_79_1169 VGND VPWR sky130_fd_sc_hd__tapvpwrvgnd_1
XANTENNA_fanout308_A fanout309/X VGND VGND VPWR VPWR sky130_fd_sc_hd__diode_2
X_2798_ _2895_/A _2920_/B _2925_/B _5828_/Q VGND VGND VPWR VPWR _2798_/X sky130_fd_sc_hd__and4b_1
Xhold310 _6036_/Q VGND VGND VPWR VPWR hold310/X sky130_fd_sc_hd__dlygate4sd3_1
X_5586_ _5696_/CLK _5586_/D fanout322/X VGND VGND VPWR VPWR _5586_/Q sky130_fd_sc_hd__dfrtp_1
Xhold343 _6102_/Q VGND VGND VPWR VPWR hold343/X sky130_fd_sc_hd__dlygate4sd3_1
Xhold332 _6101_/Q VGND VGND VPWR VPWR hold332/X sky130_fd_sc_hd__dlygate4sd3_1
XPHY_EDGE_ROW_15_Left_96 VGND VGND VPWR VPWR sky130_fd_sc_hd__decap_3
X_4537_ _4436_/S _4536_/Y _4535_/Y _4357_/X VGND VGND VPWR VPWR _4537_/X sky130_fd_sc_hd__a211o_1
Xhold321 _5620_/Q VGND VGND VPWR VPWR _3057_/B sky130_fd_sc_hd__dlygate4sd3_1
Xhold354 _6100_/Q VGND VGND VPWR VPWR hold354/X sky130_fd_sc_hd__dlygate4sd3_1
Xhold365 _5685_/Q VGND VGND VPWR VPWR hold365/X sky130_fd_sc_hd__dlygate4sd3_1
X_4468_ _4467_/A _4467_/C _3623_/A VGND VGND VPWR VPWR _4469_/B sky130_fd_sc_hd__o21ai_1
Xhold376 _5976_/Q VGND VGND VPWR VPWR hold376/X sky130_fd_sc_hd__dlygate4sd3_1
Xhold387 _5751_/Q VGND VGND VPWR VPWR hold387/X sky130_fd_sc_hd__dlygate4sd3_1
XFILLER_77_29 VGND VGND VPWR VPWR sky130_fd_sc_hd__fill_1
Xhold398 _5914_/Q VGND VGND VPWR VPWR hold398/X sky130_fd_sc_hd__dlygate4sd3_1
X_3419_ _5636_/Q hold70/X _3961_/A VGND VGND VPWR VPWR _5534_/D sky130_fd_sc_hd__mux2_1
XANTENNA__4313__B1 _5187_/B VGND VGND VPWR VPWR sky130_fd_sc_hd__diode_2
XANTENNA_fanout298_X fanout298/X VGND VGND VPWR VPWR sky130_fd_sc_hd__diode_2
XANTENNA__3667__A2 _4464_/A VGND VGND VPWR VPWR sky130_fd_sc_hd__diode_2
X_4399_ _4399_/A _4399_/B VGND VGND VPWR VPWR _4401_/A sky130_fd_sc_hd__nor2_1
X_6138_ _6163_/CLK _6138_/D fanout314/X VGND VGND VPWR VPWR hold49/A sky130_fd_sc_hd__dfrtp_1
X_6069_ _6085_/CLK _6069_/D fanout344/X VGND VGND VPWR VPWR _6069_/Q sky130_fd_sc_hd__dfrtp_1
XFILLER_58_589 VGND VGND VPWR VPWR sky130_fd_sc_hd__fill_1
XANTENNA__3650__A_N _3651_/B VGND VGND VPWR VPWR sky130_fd_sc_hd__diode_2
XFILLER_42_43 VGND VGND VPWR VPWR sky130_fd_sc_hd__decap_8
XTAP_TAPCELL_ROW_11_315 VGND VPWR sky130_fd_sc_hd__tapvpwrvgnd_1
XFILLER_5_368 VGND VGND VPWR VPWR sky130_fd_sc_hd__fill_2
XANTENNA__4552__B1 _3549_/Y VGND VGND VPWR VPWR sky130_fd_sc_hd__diode_2
XANTENNA__5762__Q _5762_/Q VGND VGND VPWR VPWR sky130_fd_sc_hd__diode_2
XANTENNA__4876__Y _4876_/Y VGND VGND VPWR VPWR sky130_fd_sc_hd__diode_2
XANTENNA__4809__S _4809_/S VGND VGND VPWR VPWR sky130_fd_sc_hd__diode_2
XFILLER_3_15 VPWR VGND VPWR VGND sky130_ef_sc_hd__decap_12
XFILLER_67_62 VPWR VGND VPWR VGND sky130_ef_sc_hd__decap_12
XANTENNA__4892__X _4892_/X VGND VGND VPWR VPWR sky130_fd_sc_hd__diode_2
XANTENNA__4607__A1 _4686_/A1 VGND VGND VPWR VPWR sky130_fd_sc_hd__diode_2
XFILLER_36_206 VPWR VGND VPWR VGND sky130_ef_sc_hd__decap_12
XANTENNA__2881__A3 _2895_/C VGND VGND VPWR VPWR sky130_fd_sc_hd__diode_2
XFILLER_17_420 VGND VGND VPWR VPWR sky130_fd_sc_hd__decap_6
XTAP_TAPCELL_ROW_19_415 VGND VPWR sky130_fd_sc_hd__tapvpwrvgnd_1
XTAP_TAPCELL_ROW_47_768 VGND VPWR sky130_fd_sc_hd__tapvpwrvgnd_1
XFILLER_32_456 VPWR VGND VPWR VGND sky130_ef_sc_hd__decap_12
XFILLER_44_294 VGND VGND VPWR VPWR sky130_fd_sc_hd__fill_2
X_3770_ _5377_/A _3869_/B _3893_/C VGND VGND VPWR VPWR _3770_/X sky130_fd_sc_hd__and3_1
XANTENNA__4791__A0 _5491_/Q VGND VGND VPWR VPWR sky130_fd_sc_hd__diode_2
X_2721_ _2834_/C VGND VGND VPWR VPWR _2830_/C sky130_fd_sc_hd__inv_2
X_5440_ _5376_/C _5434_/X _5439_/X VGND VGND VPWR VPWR _6173_/D sky130_fd_sc_hd__a21bo_1
X_5371_ _6162_/Q _5363_/B _5361_/X VGND VGND VPWR VPWR _5372_/C sky130_fd_sc_hd__a21oi_1
XANTENNA__4543__B1 _3254_/A VGND VGND VPWR VPWR sky130_fd_sc_hd__diode_2
X_4322_ hold346/X _4321_/X _4250_/B _4258_/A VGND VGND VPWR VPWR _5720_/D sky130_fd_sc_hd__a211o_1
XANTENNA__5099__A1 _5478_/Q VGND VGND VPWR VPWR sky130_fd_sc_hd__diode_2
Xfanout108 _4878_/Y VGND VGND VPWR VPWR _4948_/A2 sky130_fd_sc_hd__clkbuf_2
XANTENNA__4719__S _4735_/S VGND VGND VPWR VPWR sky130_fd_sc_hd__diode_2
X_4253_ _4315_/A _4320_/C VGND VGND VPWR VPWR _4253_/Y sky130_fd_sc_hd__nor2_1
Xfanout119 _5096_/S VGND VGND VPWR VPWR _5099_/S sky130_fd_sc_hd__buf_2
X_3204_ _4964_/A0 _5730_/Q _3204_/S VGND VGND VPWR VPWR _5475_/D sky130_fd_sc_hd__mux2_1
XTAP_TAPCELL_ROW_74_1099 VGND VPWR sky130_fd_sc_hd__tapvpwrvgnd_1
X_4184_ _5786_/Q _4167_/Y _4170_/Y _5778_/Q _4168_/Y VGND VGND VPWR VPWR _4184_/X
+ sky130_fd_sc_hd__a221o_1
X_3135_ _5913_/Q _2984_/Y _3133_/X _3134_/X _2987_/Y VGND VGND VPWR VPWR _3135_/Y
+ sky130_fd_sc_hd__o221ai_1
XANTENNA__4059__C1 _4542_/A VGND VGND VPWR VPWR sky130_fd_sc_hd__diode_2
XANTENNA__5123__B _5123_/B VGND VGND VPWR VPWR sky130_fd_sc_hd__diode_2
X_3066_ _5602_/Q _5651_/Q VGND VGND VPWR VPWR _3066_/X sky130_fd_sc_hd__or2_1
XANTENNA_fanout258_A _5726_/Q VGND VGND VPWR VPWR sky130_fd_sc_hd__diode_2
XANTENNA__3211__X _3219_/S VGND VGND VPWR VPWR sky130_fd_sc_hd__diode_2
XFILLER_35_261 VPWR VGND VPWR VGND sky130_ef_sc_hd__decap_12
XFILLER_35_283 VPWR VGND VPWR VGND sky130_ef_sc_hd__decap_12
XANTENNA__3578__B _4447_/B VGND VGND VPWR VPWR sky130_fd_sc_hd__diode_2
XFILLER_50_253 VGND VGND VPWR VPWR sky130_fd_sc_hd__fill_1
XFILLER_10_106 VGND VGND VPWR VPWR sky130_fd_sc_hd__fill_1
X_3968_ _2949_/B _2949_/D _3968_/S VGND VGND VPWR VPWR _3968_/X sky130_fd_sc_hd__mux2_1
X_2919_ _2915_/X _2916_/X _2917_/X _2918_/X _2809_/Y VGND VGND VPWR VPWR _2930_/B
+ sky130_fd_sc_hd__o41a_1
X_5707_ _5707_/CLK _5707_/D fanout293/X VGND VGND VPWR VPWR _5707_/Q sky130_fd_sc_hd__dfrtp_1
XANTENNA__4782__A0 _5520_/Q VGND VGND VPWR VPWR sky130_fd_sc_hd__diode_2
X_3899_ _5579_/Q _3917_/S _3898_/X VGND VGND VPWR VPWR _5579_/D sky130_fd_sc_hd__o21ba_1
X_5638_ _6149_/CLK _5638_/D VGND VGND VPWR VPWR _5638_/Q sky130_fd_sc_hd__dfxtp_1
X_5569_ _5707_/CLK _5569_/D fanout289/X VGND VGND VPWR VPWR _5569_/Q sky130_fd_sc_hd__dfrtp_2
Xhold162 _5898_/Q VGND VGND VPWR VPWR hold162/X sky130_fd_sc_hd__dlygate4sd3_1
Xhold151 _6076_/Q VGND VGND VPWR VPWR hold151/X sky130_fd_sc_hd__dlygate4sd3_1
Xhold140 _6066_/Q VGND VGND VPWR VPWR hold140/X sky130_fd_sc_hd__dlygate4sd3_1
Xhold184 _5772_/Q VGND VGND VPWR VPWR hold184/X sky130_fd_sc_hd__dlygate4sd3_1
Xhold195 _5792_/Q VGND VGND VPWR VPWR hold195/X sky130_fd_sc_hd__dlygate4sd3_1
Xhold173 _5813_/Q VGND VGND VPWR VPWR hold173/X sky130_fd_sc_hd__dlygate4sd3_1
XANTENNA__2848__A0 _5488_/Q VGND VGND VPWR VPWR sky130_fd_sc_hd__diode_2
XANTENNA_fanout73_A _4740_/A2 VGND VGND VPWR VPWR sky130_fd_sc_hd__diode_2
XFILLER_58_397 VGND VGND VPWR VPWR sky130_fd_sc_hd__fill_1
XFILLER_61_507 VGND VGND VPWR VPWR sky130_fd_sc_hd__fill_1
XTAP_TAPCELL_ROW_44_727 VGND VPWR sky130_fd_sc_hd__tapvpwrvgnd_1
XFILLER_41_264 VGND VGND VPWR VPWR sky130_fd_sc_hd__fill_2
XTAP_TAPCELL_ROW_24_484 VGND VPWR sky130_fd_sc_hd__tapvpwrvgnd_1
XANTENNA__5492__Q _5492_/Q VGND VGND VPWR VPWR sky130_fd_sc_hd__diode_2
XFILLER_6_677 VPWR VGND VPWR VGND sky130_ef_sc_hd__decap_12
XANTENNA__5208__B _6130_/D VGND VGND VPWR VPWR sky130_fd_sc_hd__diode_2
XANTENNA__4828__B2 _4828_/B2 VGND VGND VPWR VPWR sky130_fd_sc_hd__diode_2
XFILLER_1_393 VPWR VGND VPWR VGND sky130_ef_sc_hd__decap_12
XANTENNA__2854__A3 _2783_/B VGND VGND VPWR VPWR sky130_fd_sc_hd__diode_2
X_4940_ _5471_/Q _4658_/X _4943_/S VGND VGND VPWR VPWR _4940_/X sky130_fd_sc_hd__mux2_1
X_4871_ _5719_/Q _3764_/X _4870_/X VGND VGND VPWR VPWR _4871_/X sky130_fd_sc_hd__a21o_1
X_3822_ _5573_/Q _3834_/C VGND VGND VPWR VPWR _3822_/Y sky130_fd_sc_hd__nand2_1
XFILLER_20_404 VGND VGND VPWR VPWR sky130_fd_sc_hd__fill_2
XFILLER_20_426 VGND VGND VPWR VPWR sky130_fd_sc_hd__fill_1
X_3753_ _5802_/Q hold97/A _3879_/S VGND VGND VPWR VPWR _3753_/X sky130_fd_sc_hd__mux2_1
X_3684_ _3718_/A _3718_/B _3718_/D _3719_/C VGND VGND VPWR VPWR _3684_/X sky130_fd_sc_hd__or4b_1
XTAP_TAPCELL_ROW_76_1128 VGND VPWR sky130_fd_sc_hd__tapvpwrvgnd_1
X_5423_ _5420_/X _5422_/Y _5410_/C VGND VGND VPWR VPWR _5423_/Y sky130_fd_sc_hd__o21ai_1
X_5354_ _3929_/X _5348_/X _5356_/B VGND VGND VPWR VPWR _5376_/C sky130_fd_sc_hd__o21a_1
X_4305_ _5715_/Q _4265_/X _4304_/X _4252_/X VGND VGND VPWR VPWR _4305_/X sky130_fd_sc_hd__a22o_1
X_5285_ _6151_/Q _5285_/B VGND VGND VPWR VPWR _5286_/B sky130_fd_sc_hd__nor2_1
XANTENNA__4819__A1 _3623_/A VGND VGND VPWR VPWR sky130_fd_sc_hd__diode_2
X_4236_ _4236_/A _4236_/B VGND VGND VPWR VPWR _4236_/X sky130_fd_sc_hd__or2_1
XFILLER_74_109 VGND VGND VPWR VPWR sky130_fd_sc_hd__fill_1
X_4167_ _5901_/Q _4167_/B VGND VGND VPWR VPWR _4167_/Y sky130_fd_sc_hd__nor2_2
XPHY_EDGE_ROW_27_Left_108 VGND VGND VPWR VPWR sky130_fd_sc_hd__decap_3
X_3118_ _3130_/A _5945_/Q _4166_/B _3128_/B VGND VGND VPWR VPWR _3118_/X sky130_fd_sc_hd__or4bb_1
X_4098_ _5570_/Q _4098_/B _4098_/C _4098_/D VGND VGND VPWR VPWR _4098_/X sky130_fd_sc_hd__or4_1
X_3049_ _5647_/Q _3048_/Y _3050_/B hold367/X VGND VGND VPWR VPWR _5689_/D sky130_fd_sc_hd__a2bb2o_1
XANTENNA_fanout163_X _4735_/S VGND VGND VPWR VPWR sky130_fd_sc_hd__diode_2
XTAP_TAPCELL_ROW_21_443 VGND VPWR sky130_fd_sc_hd__tapvpwrvgnd_1
XPHY_EDGE_ROW_36_Left_117 VGND VGND VPWR VPWR sky130_fd_sc_hd__decap_3
XFILLER_3_614 VGND VGND VPWR VPWR sky130_fd_sc_hd__fill_2
XFILLER_3_658 VPWR VGND VPWR VGND sky130_ef_sc_hd__decap_12
XANTENNA__6054__RESET_B fanout283/X VGND VGND VPWR VPWR sky130_fd_sc_hd__diode_2
XFILLER_59_673 VGND VGND VPWR VPWR sky130_fd_sc_hd__fill_1
XFILLER_48_64 VPWR VGND VPWR VGND sky130_ef_sc_hd__decap_12
XPHY_EDGE_ROW_45_Left_126 VGND VGND VPWR VPWR sky130_fd_sc_hd__decap_3
XFILLER_19_526 VGND VGND VPWR VPWR sky130_fd_sc_hd__fill_1
XFILLER_73_142 VGND VGND VPWR VPWR sky130_fd_sc_hd__decap_6
XFILLER_0_27 VGND VGND VPWR VPWR sky130_fd_sc_hd__fill_1
XTAP_TAPCELL_ROW_29_543 VGND VPWR sky130_fd_sc_hd__tapvpwrvgnd_1
XFILLER_73_186 VGND VGND VPWR VPWR sky130_fd_sc_hd__fill_2
XTAP_TAPCELL_ROW_57_896 VGND VPWR sky130_fd_sc_hd__tapvpwrvgnd_1
XFILLER_27_570 VGND VGND VPWR VPWR sky130_fd_sc_hd__fill_1
XANTENNA__5487__Q _5487_/Q VGND VGND VPWR VPWR sky130_fd_sc_hd__diode_2
XFILLER_61_337 VGND VGND VPWR VPWR sky130_fd_sc_hd__fill_1
XANTENNA__4994__B1 _5038_/B1 VGND VGND VPWR VPWR sky130_fd_sc_hd__diode_2
XTAP_TAPCELL_ROW_1_190 VGND VPWR sky130_fd_sc_hd__tapvpwrvgnd_1
XANTENNA__3797__A1 _3783_/A VGND VGND VPWR VPWR sky130_fd_sc_hd__diode_2
XFILLER_80_51 VGND VGND VPWR VPWR sky130_fd_sc_hd__fill_1
XPHY_EDGE_ROW_54_Left_135 VGND VGND VPWR VPWR sky130_fd_sc_hd__decap_3
XFILLER_14_275 VGND VGND VPWR VPWR sky130_fd_sc_hd__decap_6
XFILLER_80_73 VGND VGND VPWR VPWR sky130_fd_sc_hd__fill_1
Xfanout90 _5267_/B VGND VGND VPWR VPWR _5343_/B sky130_fd_sc_hd__clkbuf_4
XANTENNA__3438__S _3442_/S VGND VGND VPWR VPWR sky130_fd_sc_hd__diode_2
XFILLER_6_452 VGND VGND VPWR VPWR sky130_fd_sc_hd__decap_3
XTAP_TAPCELL_ROW_71_1069 VGND VPWR sky130_fd_sc_hd__tapvpwrvgnd_1
XPHY_EDGE_ROW_63_Left_144 VGND VGND VPWR VPWR sky130_fd_sc_hd__decap_3
X_5070_ hold113/X _5519_/Q _5097_/S VGND VGND VPWR VPWR _5993_/D sky130_fd_sc_hd__mux2_1
XTAP_TAPCELL_ROW_9_290 VGND VPWR sky130_fd_sc_hd__tapvpwrvgnd_1
X_4021_ _5653_/Q _4024_/C VGND VGND VPWR VPWR _4022_/B sky130_fd_sc_hd__and2_1
XFILLER_29_3 VPWR VGND VPWR VGND sky130_ef_sc_hd__decap_12
XFILLER_37_345 VGND VGND VPWR VPWR sky130_fd_sc_hd__fill_1
XFILLER_64_186 VGND VGND VPWR VPWR sky130_fd_sc_hd__decap_8
X_5972_ _6107_/CLK _5972_/D fanout272/X VGND VGND VPWR VPWR _5972_/Q sky130_fd_sc_hd__dfrtp_1
XFILLER_37_389 VGND VGND VPWR VPWR sky130_fd_sc_hd__fill_1
X_4923_ _4615_/X _4950_/A2 _4950_/B1 _4922_/X VGND VGND VPWR VPWR _4923_/X sky130_fd_sc_hd__a22o_1
XFILLER_64_197 VPWR VGND VPWR VGND sky130_ef_sc_hd__decap_12
XPHY_EDGE_ROW_72_Left_153 VGND VGND VPWR VPWR sky130_fd_sc_hd__decap_3
X_4854_ _5472_/Q hold254/X _4862_/S VGND VGND VPWR VPWR _5888_/D sky130_fd_sc_hd__mux2_1
XFILLER_20_201 VGND VGND VPWR VPWR sky130_fd_sc_hd__fill_1
X_4785_ _5523_/Q hold217/X _4805_/S VGND VGND VPWR VPWR _5822_/D sky130_fd_sc_hd__mux2_1
X_3805_ _5397_/A _3902_/A2 _3804_/X VGND VGND VPWR VPWR _3805_/X sky130_fd_sc_hd__o21a_1
X_3736_ _5721_/Q _4247_/B _3734_/Y _4331_/A1 _3204_/S VGND VGND VPWR VPWR _3736_/X
+ sky130_fd_sc_hd__a311o_1
XANTENNA_fanout123_A _5026_/B1 VGND VGND VPWR VPWR sky130_fd_sc_hd__diode_2
XFILLER_9_290 VPWR VGND VPWR VGND sky130_ef_sc_hd__decap_12
X_3667_ _6103_/Q _4464_/A _5902_/Q VGND VGND VPWR VPWR _3707_/C sky130_fd_sc_hd__o21ai_1
X_3598_ _3693_/A _3598_/B _3717_/A _3715_/B VGND VGND VPWR VPWR _3617_/A sky130_fd_sc_hd__or4_1
X_5406_ _5406_/A _5427_/B VGND VGND VPWR VPWR _5407_/B sky130_fd_sc_hd__nor2_1
XFILLER_0_617 VPWR VGND VPWR VGND sky130_ef_sc_hd__decap_12
X_5337_ _6159_/Q _5337_/B VGND VGND VPWR VPWR _5338_/B sky130_fd_sc_hd__nor2_1
X_5268_ _5268_/A _5268_/B VGND VGND VPWR VPWR _5270_/A sky130_fd_sc_hd__nor2_1
X_4219_ hold103/X _4218_/X _4246_/S VGND VGND VPWR VPWR _5706_/D sky130_fd_sc_hd__mux2_1
XANTENNA__4907__S _4943_/S VGND VGND VPWR VPWR sky130_fd_sc_hd__diode_2
X_5199_ _5397_/A _5406_/A _5412_/A _6171_/Q VGND VGND VPWR VPWR _5203_/B sky130_fd_sc_hd__and4_1
XANTENNA__3228__A0 _4970_/A0 VGND VGND VPWR VPWR sky130_fd_sc_hd__diode_2
XFILLER_18_78 VGND VGND VPWR VPWR sky130_fd_sc_hd__decap_6
XTAP_TAPCELL_ROW_26_502 VGND VPWR sky130_fd_sc_hd__tapvpwrvgnd_1
XFILLER_28_389 VGND VGND VPWR VPWR sky130_fd_sc_hd__fill_1
XTAP_TAPCELL_ROW_54_855 VGND VPWR sky130_fd_sc_hd__tapvpwrvgnd_1
XANTENNA__3779__A1 _5200_/C VGND VGND VPWR VPWR sky130_fd_sc_hd__diode_2
XANTENNA__4976__B1 _3254_/A VGND VGND VPWR VPWR sky130_fd_sc_hd__diode_2
XANTENNA_fanout36_A _3725_/C VGND VGND VPWR VPWR sky130_fd_sc_hd__diode_2
XFILLER_11_223 VGND VGND VPWR VPWR sky130_fd_sc_hd__fill_1
XFILLER_34_66 VGND VGND VPWR VPWR sky130_fd_sc_hd__decap_6
XFILLER_11_245 VGND VGND VPWR VPWR sky130_fd_sc_hd__decap_3
XANTENNA__3400__A0 _2824_/C VGND VGND VPWR VPWR sky130_fd_sc_hd__diode_2
XFILLER_50_54 VGND VGND VPWR VPWR sky130_fd_sc_hd__decap_6
XANTENNA__4878__A _4878_/A VGND VGND VPWR VPWR sky130_fd_sc_hd__diode_2
XFILLER_59_52 VGND VGND VPWR VPWR sky130_fd_sc_hd__decap_4
XFILLER_3_499 VGND VGND VPWR VPWR sky130_fd_sc_hd__decap_4
XTAP_TAPCELL_ROW_6_260 VGND VPWR sky130_fd_sc_hd__tapvpwrvgnd_1
XANTENNA__4664__C1 _4720_/C1 VGND VGND VPWR VPWR sky130_fd_sc_hd__diode_2
Xfanout291 fanout292/X VGND VGND VPWR VPWR fanout291/X sky130_fd_sc_hd__clkbuf_4
XPHY_EDGE_ROW_3_Left_84 VGND VGND VPWR VPWR sky130_fd_sc_hd__decap_3
Xfanout280 fanout281/X VGND VGND VPWR VPWR fanout280/X sky130_fd_sc_hd__clkbuf_4
XANTENNA__4873__C_N _3725_/C VGND VGND VPWR VPWR sky130_fd_sc_hd__diode_2
XFILLER_75_95 VPWR VGND VPWR VGND sky130_ef_sc_hd__decap_12
XFILLER_62_668 VGND VGND VPWR VPWR sky130_fd_sc_hd__fill_1
XANTENNA__4967__A0 _4967_/A0 VGND VGND VPWR VPWR sky130_fd_sc_hd__diode_2
XANTENNA__4719__A0 _5763_/Q VGND VGND VPWR VPWR sky130_fd_sc_hd__diode_2
X_4570_ _5488_/Q _5794_/Q _4610_/S VGND VGND VPWR VPWR _4570_/X sky130_fd_sc_hd__mux2_1
XANTENNA__3942__A1 _3549_/Y VGND VGND VPWR VPWR sky130_fd_sc_hd__diode_2
X_3521_ _3538_/A _3521_/B _3521_/C VGND VGND VPWR VPWR _3521_/Y sky130_fd_sc_hd__nand3_1
XANTENNA__3963__Y _4542_/A VGND VGND VPWR VPWR sky130_fd_sc_hd__diode_2
XANTENNA_clkbuf_leaf_3_clk_A clkload0/A VGND VGND VPWR VPWR sky130_fd_sc_hd__diode_2
X_3452_ _3705_/A _6126_/Q _6127_/Q _4342_/A VGND VGND VPWR VPWR _3452_/X sky130_fd_sc_hd__or4_1
XFILLER_69_201 VGND VGND VPWR VPWR sky130_fd_sc_hd__decap_3
X_6171_ clkload8/A _6171_/D fanout285/X VGND VGND VPWR VPWR _6171_/Q sky130_fd_sc_hd__dfrtp_4
X_3383_ hold293/X _3397_/A2 _4544_/A _3382_/X VGND VGND VPWR VPWR _5509_/D sky130_fd_sc_hd__a22o_1
X_5122_ hold331/X _4536_/A _5122_/S VGND VGND VPWR VPWR _6045_/D sky130_fd_sc_hd__mux2_1
X_5053_ _4517_/A hold379/X _5054_/S VGND VGND VPWR VPWR _5977_/D sky130_fd_sc_hd__mux2_1
XANTENNA__5412__A _5412_/A VGND VGND VPWR VPWR sky130_fd_sc_hd__diode_2
X_4004_ hold473/X _5641_/Q _4005_/S VGND VGND VPWR VPWR _5640_/D sky130_fd_sc_hd__mux2_1
XFILLER_1_81 VGND VGND VPWR VPWR sky130_fd_sc_hd__decap_8
XANTENNA__4958__A0 _5094_/A1 VGND VGND VPWR VPWR sky130_fd_sc_hd__diode_2
XFILLER_25_337 VPWR VGND VPWR VGND sky130_ef_sc_hd__decap_12
X_5955_ _5963_/CLK _5955_/D fanout308/X VGND VGND VPWR VPWR _5955_/Q sky130_fd_sc_hd__dfrtp_1
XTAP_TAPCELL_ROW_51_814 VGND VPWR sky130_fd_sc_hd__tapvpwrvgnd_1
X_4906_ hold468/X _4951_/A2 _4905_/X VGND VGND VPWR VPWR _5911_/D sky130_fd_sc_hd__a21o_1
X_5886_ _6091_/CLK _5886_/D fanout348/X VGND VGND VPWR VPWR _5886_/Q sky130_fd_sc_hd__dfrtp_1
XANTENNA_fanout338_A fanout341/X VGND VGND VPWR VPWR sky130_fd_sc_hd__diode_2
X_4837_ _5521_/Q hold276/X _4862_/S VGND VGND VPWR VPWR _5871_/D sky130_fd_sc_hd__mux2_1
XANTENNA__3586__B _4427_/A VGND VGND VPWR VPWR sky130_fd_sc_hd__diode_2
XANTENNA__4186__A1 _5761_/Q VGND VGND VPWR VPWR sky130_fd_sc_hd__diode_2
XTAP_TAPCELL_ROW_31_571 VGND VPWR sky130_fd_sc_hd__tapvpwrvgnd_1
X_4768_ hold135/X _3805_/X _4776_/S VGND VGND VPWR VPWR _5806_/D sky130_fd_sc_hd__mux2_1
X_4699_ _5928_/Q _5055_/S _4747_/B1 _4698_/X VGND VGND VPWR VPWR _4699_/X sky130_fd_sc_hd__a22o_1
X_3719_ _3719_/A _3719_/B _3719_/C _3719_/D VGND VGND VPWR VPWR _3719_/X sky130_fd_sc_hd__and4_1
XANTENNA__3933__A1 _3549_/Y VGND VGND VPWR VPWR sky130_fd_sc_hd__diode_2
XTAP_TAPCELL_ROW_59_914 VGND VPWR sky130_fd_sc_hd__tapvpwrvgnd_1
Xhold11 hold11/A VGND VGND VPWR VPWR hold11/X sky130_fd_sc_hd__dlygate4sd3_1
Xhold22 hold22/A VGND VGND VPWR VPWR hold22/X sky130_fd_sc_hd__dlygate4sd3_1
XANTENNA__4637__S _4687_/S VGND VGND VPWR VPWR sky130_fd_sc_hd__diode_2
Xhold44 hold44/A VGND VGND VPWR VPWR hold44/X sky130_fd_sc_hd__dlygate4sd3_1
XFILLER_29_55 VGND VGND VPWR VPWR sky130_fd_sc_hd__fill_1
Xhold33 hold33/A VGND VGND VPWR VPWR hold33/X sky130_fd_sc_hd__dlygate4sd3_1
Xhold55 hold55/A VGND VGND VPWR VPWR hold55/X sky130_fd_sc_hd__dlygate4sd3_1
Xhold99 hold99/A VGND VGND VPWR VPWR hold99/X sky130_fd_sc_hd__dlygate4sd3_1
Xhold77 hold77/A VGND VGND VPWR VPWR hold77/X sky130_fd_sc_hd__dlygate4sd3_1
Xhold66 hold66/A VGND VGND VPWR VPWR hold66/X sky130_fd_sc_hd__dlygate4sd3_1
Xhold88 hold88/A VGND VGND VPWR VPWR hold88/X sky130_fd_sc_hd__dlygate4sd3_1
XFILLER_28_164 VGND VGND VPWR VPWR sky130_fd_sc_hd__decap_6
XTAP_TAPCELL_ROW_39_671 VGND VPWR sky130_fd_sc_hd__tapvpwrvgnd_1
XFILLER_44_613 VGND VGND VPWR VPWR sky130_fd_sc_hd__fill_1
XANTENNA__4949__A0 _5474_/Q VGND VGND VPWR VPWR sky130_fd_sc_hd__diode_2
XFILLER_16_337 VGND VGND VPWR VPWR sky130_fd_sc_hd__decap_8
XFILLER_45_54 VGND VGND VPWR VPWR sky130_fd_sc_hd__fill_2
XANTENNA__5765__Q _5765_/Q VGND VGND VPWR VPWR sky130_fd_sc_hd__diode_2
XFILLER_61_75 VGND VGND VPWR VPWR sky130_fd_sc_hd__fill_1
XANTENNA__3924__B2 _3918_/X VGND VGND VPWR VPWR sky130_fd_sc_hd__diode_2
XANTENNA__4895__X _4895_/X VGND VGND VPWR VPWR sky130_fd_sc_hd__diode_2
XANTENNA__3152__A2 _2965_/X VGND VGND VPWR VPWR sky130_fd_sc_hd__diode_2
XANTENNA__4652__A2 _4748_/A2 VGND VGND VPWR VPWR sky130_fd_sc_hd__diode_2
XFILLER_19_142 VGND VGND VPWR VPWR sky130_fd_sc_hd__decap_4
XFILLER_19_186 VPWR VGND VPWR VGND sky130_ef_sc_hd__decap_12
XFILLER_34_134 VGND VGND VPWR VPWR sky130_fd_sc_hd__decap_6
X_2952_ _3954_/A _5612_/Q VGND VGND VPWR VPWR _3208_/C sky130_fd_sc_hd__and2b_1
XTAP_TAPCELL_ROW_17_387 VGND VPWR sky130_fd_sc_hd__tapvpwrvgnd_1
XFILLER_22_318 VGND VGND VPWR VPWR sky130_fd_sc_hd__fill_1
X_5740_ clkload8/A _5740_/D fanout284/X VGND VGND VPWR VPWR _5740_/Q sky130_fd_sc_hd__dfrtp_1
XTAP_TAPCELL_ROW_17_398 VGND VPWR sky130_fd_sc_hd__tapvpwrvgnd_1
X_2883_ _2879_/X _2881_/X _2882_/X _2809_/Y VGND VGND VPWR VPWR _2901_/A sky130_fd_sc_hd__o31a_1
X_5671_ _5685_/CLK _5671_/D fanout316/X VGND VGND VPWR VPWR hold96/A sky130_fd_sc_hd__dfrtp_1
X_4622_ _4678_/A1 _4621_/X _4620_/X _4686_/B1 VGND VGND VPWR VPWR _4622_/X sky130_fd_sc_hd__o211a_1
X_4553_ _5761_/Q _4761_/A2 _3554_/Y _5863_/D VGND VGND VPWR VPWR _5761_/D sky130_fd_sc_hd__a22o_1
X_4484_ _4487_/B _4485_/B VGND VGND VPWR VPWR _4495_/B sky130_fd_sc_hd__or2_1
X_3504_ _3508_/A _3538_/B VGND VGND VPWR VPWR _3505_/A sky130_fd_sc_hd__nor2_1
XANTENNA__3391__A2 _3396_/A VGND VGND VPWR VPWR sky130_fd_sc_hd__diode_2
X_3435_ hold37/X _5582_/Q _3442_/S VGND VGND VPWR VPWR _5549_/D sky130_fd_sc_hd__mux2_1
X_6154_ _6159_/CLK _6154_/D fanout282/X VGND VGND VPWR VPWR _6154_/Q sky130_fd_sc_hd__dfrtp_1
X_3366_ _3366_/A _3366_/B _3366_/C _3366_/D VGND VGND VPWR VPWR _3367_/C sky130_fd_sc_hd__or4_1
X_6085_ _6085_/CLK _6085_/D fanout333/X VGND VGND VPWR VPWR _6085_/Q sky130_fd_sc_hd__dfrtp_1
X_3297_ _5406_/A _5983_/Q VGND VGND VPWR VPWR _3345_/A sky130_fd_sc_hd__and2b_1
X_5105_ hold451/X _5412_/A _5109_/S VGND VGND VPWR VPWR _6028_/D sky130_fd_sc_hd__mux2_1
X_5036_ _4725_/X _4979_/A _4979_/B _4964_/X VGND VGND VPWR VPWR _5036_/X sky130_fd_sc_hd__a22o_1
XFILLER_26_657 VGND VGND VPWR VPWR sky130_fd_sc_hd__decap_4
XFILLER_25_156 VGND VGND VPWR VPWR sky130_fd_sc_hd__decap_4
XFILLER_26_668 VPWR VGND VPWR VGND sky130_ef_sc_hd__decap_12
XTAP_TAPCELL_ROW_36_630 VGND VPWR sky130_fd_sc_hd__tapvpwrvgnd_1
XTAP_TAPCELL_ROW_64_983 VGND VPWR sky130_fd_sc_hd__tapvpwrvgnd_1
X_5938_ _6032_/CLK _5938_/D fanout300/X VGND VGND VPWR VPWR _5938_/Q sky130_fd_sc_hd__dfrtp_1
XANTENNA__3597__A _4522_/C VGND VGND VPWR VPWR sky130_fd_sc_hd__diode_2
XANTENNA_fanout243_X _2744_/A VGND VGND VPWR VPWR sky130_fd_sc_hd__diode_2
XANTENNA__2957__A2 _3426_/D VGND VGND VPWR VPWR sky130_fd_sc_hd__diode_2
X_5869_ _6115_/CLK _5869_/D fanout336/X VGND VGND VPWR VPWR _5869_/Q sky130_fd_sc_hd__dfrtp_1
XFILLER_21_351 VPWR VGND VPWR VGND sky130_ef_sc_hd__decap_12
XFILLER_0_211 VPWR VGND VPWR VGND sky130_ef_sc_hd__decap_12
XANTENNA__4331__A1 _4331_/A1 VGND VGND VPWR VPWR sky130_fd_sc_hd__diode_2
XANTENNA__3134__A2 _2977_/Y VGND VGND VPWR VPWR sky130_fd_sc_hd__diode_2
XANTENNA__2893__A1 _2895_/A VGND VGND VPWR VPWR sky130_fd_sc_hd__diode_2
XFILLER_0_277 VGND VGND VPWR VPWR sky130_fd_sc_hd__decap_3
XFILLER_56_97 VGND VGND VPWR VPWR sky130_fd_sc_hd__decap_8
XFILLER_29_484 VPWR VGND VPWR VGND sky130_ef_sc_hd__decap_12
XFILLER_16_167 VGND VGND VPWR VPWR sky130_fd_sc_hd__decap_3
XANTENNA__4398__A1 _4813_/A1 VGND VGND VPWR VPWR sky130_fd_sc_hd__diode_2
XANTENNA_clkbuf_2_0__f_clk_X clkload0/A VGND VGND VPWR VPWR sky130_fd_sc_hd__diode_2
XFILLER_32_638 VGND VGND VPWR VPWR sky130_fd_sc_hd__decap_6
XTAP_TAPCELL_ROW_14_357 VGND VPWR sky130_fd_sc_hd__tapvpwrvgnd_1
XTAP_TAPCELL_ROW_42_699 VGND VPWR sky130_fd_sc_hd__tapvpwrvgnd_1
XFILLER_68_7 VGND VGND VPWR VPWR sky130_fd_sc_hd__fill_1
XFILLER_8_377 VGND VGND VPWR VPWR sky130_fd_sc_hd__decap_6
X_3220_ _4866_/S _5900_/Q VGND VGND VPWR VPWR _4867_/A sky130_fd_sc_hd__nand2b_1
XANTENNA__3302__A_N _5397_/A VGND VGND VPWR VPWR sky130_fd_sc_hd__diode_2
X_3151_ _2993_/X _3149_/X _3150_/X _3138_/B VGND VGND VPWR VPWR _3151_/X sky130_fd_sc_hd__a31o_1
XFILLER_39_215 VGND VGND VPWR VPWR sky130_fd_sc_hd__decap_8
XFILLER_79_395 VGND VGND VPWR VPWR sky130_fd_sc_hd__decap_6
XFILLER_11_3 VPWR VGND VPWR VGND sky130_ef_sc_hd__decap_12
X_3082_ _5591_/Q _5677_/Q VGND VGND VPWR VPWR _3086_/A sky130_fd_sc_hd__xor2_1
XFILLER_35_443 VGND VGND VPWR VPWR sky130_fd_sc_hd__decap_4
XTAP_TAPCELL_ROW_61_942 VGND VPWR sky130_fd_sc_hd__tapvpwrvgnd_1
X_3984_ _5659_/Q _5643_/Q VGND VGND VPWR VPWR _4005_/S sky130_fd_sc_hd__and2_2
XFILLER_22_126 VGND VGND VPWR VPWR sky130_fd_sc_hd__decap_3
X_5723_ _5723_/CLK _5723_/D _3183_/B VGND VGND VPWR VPWR _5723_/Q sky130_fd_sc_hd__dfrtp_1
X_2935_ _5470_/Q _2935_/B VGND VGND VPWR VPWR _2935_/X sky130_fd_sc_hd__or2_1
XFILLER_31_671 VGND VGND VPWR VPWR sky130_fd_sc_hd__fill_1
X_2866_ _6012_/Q _2927_/B1 _2921_/B1 _5996_/Q VGND VGND VPWR VPWR _2868_/B sky130_fd_sc_hd__a22o_1
X_5654_ _5685_/CLK _5654_/D fanout316/X VGND VGND VPWR VPWR _5654_/Q sky130_fd_sc_hd__dfrtp_1
X_4605_ _5949_/Q _5765_/Q _4623_/S VGND VGND VPWR VPWR _4605_/X sky130_fd_sc_hd__mux2_1
Xhold300 _5826_/Q VGND VGND VPWR VPWR hold300/X sky130_fd_sc_hd__dlygate4sd3_1
X_2797_ _6114_/Q _6115_/Q VGND VGND VPWR VPWR _2797_/X sky130_fd_sc_hd__and2_2
Xhold311 _6055_/Q VGND VGND VPWR VPWR hold311/X sky130_fd_sc_hd__dlygate4sd3_1
X_5585_ _5697_/CLK _5585_/D fanout319/X VGND VGND VPWR VPWR _5585_/Q sky130_fd_sc_hd__dfrtp_1
Xhold344 _5838_/Q VGND VGND VPWR VPWR hold344/X sky130_fd_sc_hd__dlygate4sd3_1
Xhold333 _5783_/Q VGND VGND VPWR VPWR hold333/X sky130_fd_sc_hd__dlygate4sd3_1
XANTENNA_fanout203_A _2871_/C VGND VGND VPWR VPWR sky130_fd_sc_hd__diode_2
X_4536_ _4536_/A _4536_/B VGND VGND VPWR VPWR _4536_/Y sky130_fd_sc_hd__xnor2_1
Xhold322 _3057_/X VGND VGND VPWR VPWR _5622_/D sky130_fd_sc_hd__dlygate4sd3_1
Xhold366 _6098_/Q VGND VGND VPWR VPWR hold366/X sky130_fd_sc_hd__dlygate4sd3_1
Xhold355 _6156_/Q VGND VGND VPWR VPWR hold355/X sky130_fd_sc_hd__dlygate4sd3_1
Xhold377 _5971_/Q VGND VGND VPWR VPWR hold377/X sky130_fd_sc_hd__dlygate4sd3_1
X_4467_ _4467_/A _4487_/A _4467_/C VGND VGND VPWR VPWR _4485_/B sky130_fd_sc_hd__or3_1
XANTENNA__3880__A _6174_/Q VGND VGND VPWR VPWR sky130_fd_sc_hd__diode_2
Xhold388 _5711_/Q VGND VGND VPWR VPWR hold388/X sky130_fd_sc_hd__dlygate4sd3_1
Xhold399 _5938_/Q VGND VGND VPWR VPWR hold399/X sky130_fd_sc_hd__dlygate4sd3_1
X_3418_ _5635_/Q hold23/X _3961_/A VGND VGND VPWR VPWR hold24/A sky130_fd_sc_hd__mux2_1
X_4398_ _4813_/A1 _4475_/B _4397_/X VGND VGND VPWR VPWR _5739_/D sky130_fd_sc_hd__a21bo_1
X_6137_ _6144_/CLK _6137_/D fanout331/X VGND VGND VPWR VPWR _6137_/Q sky130_fd_sc_hd__dfrtp_1
X_3349_ _3749_/A _3364_/C _3349_/C _6046_/Q VGND VGND VPWR VPWR _3350_/D sky130_fd_sc_hd__or4b_1
XANTENNA_fanout193_X _5200_/C VGND VGND VPWR VPWR sky130_fd_sc_hd__diode_2
X_6068_ _6092_/CLK _6068_/D fanout339/X VGND VGND VPWR VPWR _6068_/Q sky130_fd_sc_hd__dfrtp_1
X_5019_ hold423/X _5025_/A2 _5018_/X VGND VGND VPWR VPWR _5955_/D sky130_fd_sc_hd__a21o_1
XFILLER_38_281 VGND VGND VPWR VPWR sky130_fd_sc_hd__decap_8
XFILLER_26_465 VGND VGND VPWR VPWR sky130_fd_sc_hd__decap_8
XFILLER_13_104 VGND VGND VPWR VPWR sky130_fd_sc_hd__fill_1
XFILLER_13_115 VPWR VGND VPWR VGND sky130_ef_sc_hd__decap_12
XFILLER_14_627 VGND VGND VPWR VPWR sky130_fd_sc_hd__fill_1
XFILLER_26_487 VPWR VGND VPWR VGND sky130_ef_sc_hd__decap_12
XANTENNA__4650__S _4674_/S VGND VGND VPWR VPWR sky130_fd_sc_hd__diode_2
XTAP_TAPCELL_ROW_11_316 VGND VPWR sky130_fd_sc_hd__tapvpwrvgnd_1
XANTENNA__4552__A1 _5760_/Q VGND VGND VPWR VPWR sky130_fd_sc_hd__diode_2
XANTENNA_clkbuf_leaf_43_clk_A clkload1/A VGND VGND VPWR VPWR sky130_fd_sc_hd__diode_2
XFILLER_3_27 VPWR VGND VPWR VGND sky130_ef_sc_hd__decap_12
XFILLER_67_74 VGND VGND VPWR VPWR sky130_fd_sc_hd__decap_6
XFILLER_76_365 VGND VGND VPWR VPWR sky130_fd_sc_hd__decap_4
XTAP_TAPCELL_ROW_19_416 VGND VPWR sky130_fd_sc_hd__tapvpwrvgnd_1
XFILLER_36_218 VPWR VGND VPWR VGND sky130_ef_sc_hd__decap_12
XTAP_TAPCELL_ROW_47_769 VGND VPWR sky130_fd_sc_hd__tapvpwrvgnd_1
XANTENNA__5032__A2 _5038_/A2 VGND VGND VPWR VPWR sky130_fd_sc_hd__diode_2
XANTENNA__3043__B2 _5474_/Q VGND VGND VPWR VPWR sky130_fd_sc_hd__diode_2
XANTENNA__3043__A1 _5494_/Q VGND VGND VPWR VPWR sky130_fd_sc_hd__diode_2
XFILLER_13_671 VGND VGND VPWR VPWR sky130_fd_sc_hd__fill_1
XFILLER_20_608 VGND VGND VPWR VPWR sky130_fd_sc_hd__decap_4
XFILLER_32_468 VGND VGND VPWR VPWR sky130_fd_sc_hd__fill_1
XANTENNA__6114__Q _6114_/Q VGND VGND VPWR VPWR sky130_fd_sc_hd__diode_2
X_2720_ _5719_/Q VGND VGND VPWR VPWR _2720_/Y sky130_fd_sc_hd__inv_2
XFILLER_40_490 VGND VGND VPWR VPWR sky130_fd_sc_hd__fill_1
XFILLER_59_3 VGND VGND VPWR VPWR sky130_fd_sc_hd__decap_8
X_5370_ _5372_/A _5372_/B VGND VGND VPWR VPWR _5370_/Y sky130_fd_sc_hd__nor2_1
XANTENNA__4543__A1 _4943_/S VGND VGND VPWR VPWR sky130_fd_sc_hd__diode_2
X_4321_ _4141_/B _4152_/B _4338_/B _4320_/X VGND VGND VPWR VPWR _4321_/X sky130_fd_sc_hd__o211a_1
X_4252_ _5701_/Q _4329_/A VGND VGND VPWR VPWR _4252_/X sky130_fd_sc_hd__or2_1
Xfanout109 _4855_/S VGND VGND VPWR VPWR _4863_/S sky130_fd_sc_hd__buf_4
X_3203_ _4973_/A0 _5474_/Q _3203_/S VGND VGND VPWR VPWR _5474_/D sky130_fd_sc_hd__mux2_1
X_4183_ _5937_/Q _5761_/Q _4241_/S VGND VGND VPWR VPWR _4183_/X sky130_fd_sc_hd__mux2_1
XANTENNA__2842__A_N _4967_/A0 VGND VGND VPWR VPWR sky130_fd_sc_hd__diode_2
X_3134_ _5921_/Q _2977_/Y _2988_/B VGND VGND VPWR VPWR _3134_/X sky130_fd_sc_hd__a21o_1
XFILLER_67_387 VGND VGND VPWR VPWR sky130_fd_sc_hd__fill_1
XANTENNA__4735__S _4735_/S VGND VGND VPWR VPWR sky130_fd_sc_hd__diode_2
X_3065_ _5602_/Q _5651_/Q VGND VGND VPWR VPWR _3065_/Y sky130_fd_sc_hd__nand2_1
XFILLER_35_273 VGND VGND VPWR VPWR sky130_fd_sc_hd__decap_3
XANTENNA__5023__A2 _5043_/A2 VGND VGND VPWR VPWR sky130_fd_sc_hd__diode_2
XFILLER_35_295 VPWR VGND VPWR VGND sky130_ef_sc_hd__decap_12
X_3967_ _3967_/A _3967_/B VGND VGND VPWR VPWR _5615_/D sky130_fd_sc_hd__xnor2_1
X_2918_ _2895_/A _6082_/Q _2783_/B _2918_/B1 _6086_/Q VGND VGND VPWR VPWR _2918_/X
+ sky130_fd_sc_hd__a32o_1
X_5706_ _5792_/CLK _5706_/D fanout296/X VGND VGND VPWR VPWR _5706_/Q sky130_fd_sc_hd__dfrtp_1
XANTENNA__2793__B1 _2917_/A2 VGND VGND VPWR VPWR sky130_fd_sc_hd__diode_2
X_3898_ _3916_/S _3908_/B _3896_/Y _3897_/X _3917_/S VGND VGND VPWR VPWR _3898_/X
+ sky130_fd_sc_hd__o311a_1
Xclkbuf_leaf_30_clk clkload2/A VGND VGND VPWR VPWR _6088_/CLK sky130_fd_sc_hd__clkbuf_8
X_2849_ _2831_/B _5522_/Q _2842_/B _2831_/A VGND VGND VPWR VPWR _2849_/X sky130_fd_sc_hd__a211o_1
X_5637_ _5645_/CLK _5637_/D VGND VGND VPWR VPWR _5637_/Q sky130_fd_sc_hd__dfxtp_1
X_5568_ _5707_/CLK _5568_/D fanout291/X VGND VGND VPWR VPWR _5568_/Q sky130_fd_sc_hd__dfrtp_1
XANTENNA_fanout206_X _2871_/B VGND VGND VPWR VPWR sky130_fd_sc_hd__diode_2
X_4519_ _4517_/Y _4519_/B VGND VGND VPWR VPWR _4520_/B sky130_fd_sc_hd__nand2b_1
Xhold141 _6117_/Q VGND VGND VPWR VPWR hold141/X sky130_fd_sc_hd__dlygate4sd3_1
Xhold152 _5507_/Q VGND VGND VPWR VPWR hold152/X sky130_fd_sc_hd__dlygate4sd3_1
Xhold130 _5803_/Q VGND VGND VPWR VPWR hold130/X sky130_fd_sc_hd__dlygate4sd3_1
Xhold185 _5774_/Q VGND VGND VPWR VPWR hold185/X sky130_fd_sc_hd__dlygate4sd3_1
X_5499_ _6149_/CLK _5499_/D VGND VGND VPWR VPWR hold40/A sky130_fd_sc_hd__dfxtp_1
Xhold163 _5848_/Q VGND VGND VPWR VPWR hold163/X sky130_fd_sc_hd__dlygate4sd3_1
Xhold174 _5515_/Q VGND VGND VPWR VPWR hold174/X sky130_fd_sc_hd__dlygate4sd3_1
Xhold196 _6000_/Q VGND VGND VPWR VPWR hold196/X sky130_fd_sc_hd__dlygate4sd3_1
XANTENNA__4645__S _4687_/S VGND VGND VPWR VPWR sky130_fd_sc_hd__diode_2
XTAP_TAPCELL_ROW_44_728 VGND VPWR sky130_fd_sc_hd__tapvpwrvgnd_1
XANTENNA__5014__A2 _5038_/A2 VGND VGND VPWR VPWR sky130_fd_sc_hd__diode_2
XFILLER_53_87 VGND VGND VPWR VPWR sky130_fd_sc_hd__fill_1
XFILLER_14_468 VGND VGND VPWR VPWR sky130_fd_sc_hd__decap_8
XTAP_TAPCELL_ROW_24_474 VGND VPWR sky130_fd_sc_hd__tapvpwrvgnd_1
XTAP_TAPCELL_ROW_24_485 VGND VPWR sky130_fd_sc_hd__tapvpwrvgnd_1
XFILLER_41_287 VGND VGND VPWR VPWR sky130_fd_sc_hd__decap_6
Xclkbuf_leaf_21_clk clkload2/A VGND VGND VPWR VPWR _6142_/CLK sky130_fd_sc_hd__clkbuf_8
XFILLER_22_490 VGND VGND VPWR VPWR sky130_fd_sc_hd__decap_3
XANTENNA__4525__A1 _4522_/C VGND VGND VPWR VPWR sky130_fd_sc_hd__diode_2
XANTENNA__5208__C _6129_/D VGND VGND VPWR VPWR sky130_fd_sc_hd__diode_2
XFILLER_6_689 VGND VGND VPWR VPWR sky130_fd_sc_hd__decap_8
XFILLER_5_188 VGND VGND VPWR VPWR sky130_fd_sc_hd__decap_6
XANTENNA__4828__A2 _2964_/B VGND VGND VPWR VPWR sky130_fd_sc_hd__diode_2
XFILLER_37_505 VGND VGND VPWR VPWR sky130_fd_sc_hd__decap_8
XANTENNA__2864__A _2864_/A VGND VGND VPWR VPWR sky130_fd_sc_hd__diode_2
XANTENNA__6109__Q _6109_/Q VGND VGND VPWR VPWR sky130_fd_sc_hd__diode_2
XFILLER_76_195 VGND VGND VPWR VPWR sky130_fd_sc_hd__fill_1
XFILLER_17_273 VGND VGND VPWR VPWR sky130_fd_sc_hd__decap_6
X_4870_ _4870_/A1 _3905_/C _4167_/Y VGND VGND VPWR VPWR _4870_/X sky130_fd_sc_hd__a21o_1
XANTENNA__5005__A2 _5027_/A2 VGND VGND VPWR VPWR sky130_fd_sc_hd__diode_2
X_3821_ _3906_/A1 _3906_/A2 _3818_/X _3820_/X VGND VGND VPWR VPWR _4100_/C sky130_fd_sc_hd__a31oi_2
Xclkbuf_leaf_12_clk clkbuf_leaf_9_clk/A VGND VGND VPWR VPWR _5723_/CLK sky130_fd_sc_hd__clkbuf_8
X_3752_ _5901_/Q _3752_/B VGND VGND VPWR VPWR _3913_/B sky130_fd_sc_hd__or2_2
XFILLER_9_461 VGND VGND VPWR VPWR sky130_fd_sc_hd__decap_8
X_3683_ _4452_/A _5972_/Q _3620_/B _3620_/C _3682_/Y VGND VGND VPWR VPWR _3719_/C
+ sky130_fd_sc_hd__o2111a_1
XTAP_TAPCELL_ROW_76_1129 VGND VPWR sky130_fd_sc_hd__tapvpwrvgnd_1
X_5422_ _5430_/B _5422_/B VGND VGND VPWR VPWR _5422_/Y sky130_fd_sc_hd__nor2_1
X_5353_ _5353_/A _5353_/B VGND VGND VPWR VPWR _5356_/B sky130_fd_sc_hd__nor2_1
X_4304_ _5708_/Q _4303_/X _4310_/S VGND VGND VPWR VPWR _4304_/X sky130_fd_sc_hd__mux2_1
X_5284_ _6151_/Q _5285_/B VGND VGND VPWR VPWR _5286_/A sky130_fd_sc_hd__and2_1
X_4235_ _4234_/X _4232_/X _4235_/S VGND VGND VPWR VPWR _4236_/B sky130_fd_sc_hd__mux2_1
X_4166_ _5863_/Q _4166_/B _4166_/C VGND VGND VPWR VPWR _4166_/X sky130_fd_sc_hd__and3_1
X_3117_ _4166_/B _3128_/B _3130_/A _5961_/Q VGND VGND VPWR VPWR _3117_/X sky130_fd_sc_hd__and4_1
XANTENNA_fanout270_A _5476_/Q VGND VGND VPWR VPWR sky130_fd_sc_hd__diode_2
XANTENNA__3589__B _4399_/A VGND VGND VPWR VPWR sky130_fd_sc_hd__diode_2
X_4097_ _4098_/B _4098_/C _4098_/D _5570_/Q VGND VGND VPWR VPWR _4097_/Y sky130_fd_sc_hd__o31ai_1
X_3048_ _5675_/Q _5687_/Q VGND VGND VPWR VPWR _3048_/Y sky130_fd_sc_hd__nand2_1
XFILLER_24_711 VGND VGND VPWR VPWR sky130_fd_sc_hd__fill_2
XFILLER_23_221 VGND VGND VPWR VPWR sky130_fd_sc_hd__fill_1
X_4999_ hold429/X _5027_/A2 _4998_/X VGND VGND VPWR VPWR _5945_/D sky130_fd_sc_hd__a21o_1
XANTENNA__4755__B2 _3554_/Y VGND VGND VPWR VPWR sky130_fd_sc_hd__diode_2
XFILLER_11_449 VGND VGND VPWR VPWR sky130_fd_sc_hd__decap_8
XTAP_TAPCELL_ROW_21_444 VGND VPWR sky130_fd_sc_hd__tapvpwrvgnd_1
XFILLER_23_57 VGND VGND VPWR VPWR sky130_fd_sc_hd__decap_3
XANTENNA__6131__D _6131_/D VGND VGND VPWR VPWR sky130_fd_sc_hd__diode_2
XANTENNA__5180__A1 _2744_/A VGND VGND VPWR VPWR sky130_fd_sc_hd__diode_2
XFILLER_48_76 VGND VGND VPWR VPWR sky130_fd_sc_hd__fill_1
XFILLER_74_622 VGND VGND VPWR VPWR sky130_fd_sc_hd__fill_1
XANTENNA__4691__B1 _4747_/B1 VGND VGND VPWR VPWR sky130_fd_sc_hd__diode_2
XANTENNA_fanout69_X _5127_/B VGND VGND VPWR VPWR sky130_fd_sc_hd__diode_2
XFILLER_58_195 VGND VGND VPWR VPWR sky130_fd_sc_hd__fill_1
XTAP_TAPCELL_ROW_29_544 VGND VPWR sky130_fd_sc_hd__tapvpwrvgnd_1
XFILLER_61_327 VGND VGND VPWR VPWR sky130_fd_sc_hd__fill_1
XTAP_TAPCELL_ROW_57_897 VGND VPWR sky130_fd_sc_hd__tapvpwrvgnd_1
XFILLER_46_379 VGND VGND VPWR VPWR sky130_fd_sc_hd__decap_6
XTAP_TAPCELL_ROW_1_191 VGND VPWR sky130_fd_sc_hd__tapvpwrvgnd_1
XFILLER_14_221 VPWR VGND VPWR VGND sky130_ef_sc_hd__decap_12
XFILLER_80_41 VGND VGND VPWR VPWR sky130_fd_sc_hd__decap_6
XANTENNA__4746__A1 _4973_/A0 VGND VGND VPWR VPWR sky130_fd_sc_hd__diode_2
Xfanout91 _5267_/B VGND VGND VPWR VPWR _5337_/B sky130_fd_sc_hd__dlymetal6s2s_1
XANTENNA__4404__A _4404_/A VGND VGND VPWR VPWR sky130_fd_sc_hd__diode_2
XANTENNA__4898__X _4898_/X VGND VGND VPWR VPWR sky130_fd_sc_hd__diode_2
XANTENNA__5171__A1 _5477_/Q VGND VGND VPWR VPWR sky130_fd_sc_hd__diode_2
XFILLER_6_475 VGND VGND VPWR VPWR sky130_fd_sc_hd__fill_1
XANTENNA__2859__A _2864_/A VGND VGND VPWR VPWR sky130_fd_sc_hd__diode_2
XFILLER_69_449 VGND VGND VPWR VPWR sky130_fd_sc_hd__fill_1
XTAP_TAPCELL_ROW_9_291 VGND VPWR sky130_fd_sc_hd__tapvpwrvgnd_1
XFILLER_2_681 VPWR VGND VPWR VGND sky130_ef_sc_hd__decap_12
X_4020_ hold11/X _4020_/B _4024_/C VGND VGND VPWR VPWR _5652_/D sky130_fd_sc_hd__nor3_1
Xclkbuf_leaf_1_clk clkload0/A VGND VGND VPWR VPWR _6026_/CLK sky130_fd_sc_hd__clkbuf_8
XANTENNA__4682__A0 _5474_/Q VGND VGND VPWR VPWR sky130_fd_sc_hd__diode_2
X_5971_ clkload3/A _5971_/D fanout272/X VGND VGND VPWR VPWR _5971_/Q sky130_fd_sc_hd__dfrtp_1
X_4922_ _5493_/Q _4610_/X _4949_/S VGND VGND VPWR VPWR _4922_/X sky130_fd_sc_hd__mux2_1
X_4853_ _5471_/Q hold156/X _4862_/S VGND VGND VPWR VPWR _5887_/D sky130_fd_sc_hd__mux2_1
X_4784_ _5522_/Q hold239/X _4810_/S VGND VGND VPWR VPWR _5821_/D sky130_fd_sc_hd__mux2_1
X_3804_ _4427_/A _4762_/C _3803_/X _3845_/B VGND VGND VPWR VPWR _3804_/X sky130_fd_sc_hd__a211o_1
X_3735_ _5721_/Q _4247_/B VGND VGND VPWR VPWR _4255_/C sky130_fd_sc_hd__nand2_1
XANTENNA__5162__A1 _5472_/Q VGND VGND VPWR VPWR sky130_fd_sc_hd__diode_2
X_3666_ _4354_/S _4386_/S VGND VGND VPWR VPWR _5187_/B sky130_fd_sc_hd__or2_2
X_5405_ _5406_/A _5427_/B VGND VGND VPWR VPWR _5415_/A sky130_fd_sc_hd__and2_1
Xclkload50 _6113_/CLK VGND VGND VPWR VPWR clkload50/X sky130_fd_sc_hd__clkbuf_8
X_3597_ _4522_/C _6060_/Q VGND VGND VPWR VPWR _3715_/B sky130_fd_sc_hd__xor2_1
X_5336_ _6159_/Q _5337_/B VGND VGND VPWR VPWR _5338_/A sky130_fd_sc_hd__and2_1
XFILLER_0_629 VPWR VGND VPWR VGND sky130_ef_sc_hd__decap_12
X_5267_ _6148_/Q _5267_/B VGND VGND VPWR VPWR _5268_/B sky130_fd_sc_hd__nor2_1
X_4218_ _4218_/A _4218_/B VGND VGND VPWR VPWR _4218_/X sky130_fd_sc_hd__or2_1
X_5198_ _5198_/A _5198_/B _3268_/C VGND VGND VPWR VPWR _5206_/C sky130_fd_sc_hd__or3b_1
XFILLER_28_313 VGND VGND VPWR VPWR sky130_fd_sc_hd__fill_1
X_4149_ _5458_/B _5458_/C VGND VGND VPWR VPWR _5459_/B sky130_fd_sc_hd__and2_1
XFILLER_56_655 VGND VGND VPWR VPWR sky130_fd_sc_hd__fill_1
XFILLER_55_143 VGND VGND VPWR VPWR sky130_fd_sc_hd__decap_8
XFILLER_28_346 VGND VGND VPWR VPWR sky130_fd_sc_hd__decap_4
XANTENNA__3228__A1 _5493_/Q VGND VGND VPWR VPWR sky130_fd_sc_hd__diode_2
XFILLER_56_699 VGND VGND VPWR VPWR sky130_fd_sc_hd__fill_1
XTAP_TAPCELL_ROW_26_503 VGND VPWR sky130_fd_sc_hd__tapvpwrvgnd_1
XFILLER_43_327 VGND VGND VPWR VPWR sky130_fd_sc_hd__decap_6
XFILLER_43_349 VGND VGND VPWR VPWR sky130_fd_sc_hd__fill_1
XTAP_TAPCELL_ROW_54_856 VGND VPWR sky130_fd_sc_hd__tapvpwrvgnd_1
XFILLER_11_213 VGND VGND VPWR VPWR sky130_fd_sc_hd__decap_4
XFILLER_51_393 VGND VGND VPWR VPWR sky130_fd_sc_hd__fill_1
XANTENNA__3400__A1 _5517_/Q VGND VGND VPWR VPWR sky130_fd_sc_hd__diode_2
XFILLER_11_279 VGND VGND VPWR VPWR sky130_fd_sc_hd__fill_1
Xclkload0 clkload0/A VGND VGND VPWR VPWR clkload0/Y sky130_fd_sc_hd__inv_6
XANTENNA__4878__B _4878_/B VGND VGND VPWR VPWR sky130_fd_sc_hd__diode_2
XANTENNA__5153__A1 _5491_/Q VGND VGND VPWR VPWR sky130_fd_sc_hd__diode_2
XTAP_TAPCELL_ROW_6_261 VGND VPWR sky130_fd_sc_hd__tapvpwrvgnd_1
XTAP_TAPCELL_ROW_6_250 VGND VPWR sky130_fd_sc_hd__tapvpwrvgnd_1
Xfanout270 _5476_/Q VGND VGND VPWR VPWR _4967_/A0 sky130_fd_sc_hd__clkbuf_4
Xfanout292 fanout298/X VGND VGND VPWR VPWR fanout292/X sky130_fd_sc_hd__clkbuf_2
Xfanout281 fanout287/X VGND VGND VPWR VPWR fanout281/X sky130_fd_sc_hd__clkbuf_4
XFILLER_19_335 VGND VGND VPWR VPWR sky130_fd_sc_hd__fill_1
XFILLER_61_113 VGND VGND VPWR VPWR sky130_fd_sc_hd__decap_4
XANTENNA__4833__S _4863_/S VGND VGND VPWR VPWR sky130_fd_sc_hd__diode_2
XFILLER_34_327 VGND VGND VPWR VPWR sky130_fd_sc_hd__decap_8
XANTENNA__3624__D1 _4873_/A VGND VGND VPWR VPWR sky130_fd_sc_hd__diode_2
XFILLER_15_596 VGND VGND VPWR VPWR sky130_fd_sc_hd__fill_1
X_3520_ _6116_/D _3517_/B _3492_/X _6137_/D VGND VGND VPWR VPWR _3550_/B sky130_fd_sc_hd__a22o_2
XFILLER_6_283 VPWR VGND VPWR VGND sky130_ef_sc_hd__decap_12
X_3451_ _5589_/Q hold54/X _3451_/S VGND VGND VPWR VPWR _5564_/D sky130_fd_sc_hd__mux2_1
XANTENNA__5144__A1 _5520_/Q VGND VGND VPWR VPWR sky130_fd_sc_hd__diode_2
XANTENNA__3155__B1 _2977_/Y VGND VGND VPWR VPWR sky130_fd_sc_hd__diode_2
X_6170_ clkload8/A _6170_/D fanout285/X VGND VGND VPWR VPWR _6170_/Q sky130_fd_sc_hd__dfrtp_1
XFILLER_41_3 VGND VGND VPWR VPWR sky130_fd_sc_hd__decap_8
X_3382_ _5984_/Q _6028_/Q _3394_/S VGND VGND VPWR VPWR _3382_/X sky130_fd_sc_hd__mux2_1
X_5121_ hold307/X _4517_/A _5122_/S VGND VGND VPWR VPWR _6044_/D sky130_fd_sc_hd__mux2_1
XFILLER_69_279 VGND VGND VPWR VPWR sky130_fd_sc_hd__fill_1
X_5052_ _4522_/B hold376/X _5054_/S VGND VGND VPWR VPWR _5976_/D sky130_fd_sc_hd__mux2_1
X_4003_ _5639_/Q _5640_/Q _4005_/S VGND VGND VPWR VPWR _5639_/D sky130_fd_sc_hd__mux2_1
XANTENNA__5927__RESET_B fanout307/X VGND VGND VPWR VPWR sky130_fd_sc_hd__diode_2
XANTENNA__4407__B1 _4404_/A VGND VGND VPWR VPWR sky130_fd_sc_hd__diode_2
XFILLER_25_349 VGND VGND VPWR VPWR sky130_fd_sc_hd__fill_1
X_5954_ _6142_/CLK _5954_/D fanout326/X VGND VGND VPWR VPWR _5954_/Q sky130_fd_sc_hd__dfrtp_1
X_4905_ _4567_/X _4947_/A2 _4947_/B1 _4904_/X VGND VGND VPWR VPWR _4905_/X sky130_fd_sc_hd__a22o_1
X_5885_ _6094_/CLK _5885_/D fanout344/X VGND VGND VPWR VPWR _5885_/Q sky130_fd_sc_hd__dfrtp_1
XTAP_TAPCELL_ROW_51_815 VGND VPWR sky130_fd_sc_hd__tapvpwrvgnd_1
XFILLER_21_500 VGND VGND VPWR VPWR sky130_fd_sc_hd__fill_2
XFILLER_33_371 VGND VGND VPWR VPWR sky130_fd_sc_hd__fill_1
X_4836_ _5520_/Q hold302/X _4863_/S VGND VGND VPWR VPWR _5870_/D sky130_fd_sc_hd__mux2_1
XTAP_TAPCELL_ROW_31_572 VGND VPWR sky130_fd_sc_hd__tapvpwrvgnd_1
X_4767_ hold172/X _3792_/X _4776_/S VGND VGND VPWR VPWR _5805_/D sky130_fd_sc_hd__mux2_1
X_4698_ _5794_/Q _2843_/B _4746_/S VGND VGND VPWR VPWR _4698_/X sky130_fd_sc_hd__mux2_1
X_3718_ _3718_/A _3718_/B _3718_/C _3718_/D VGND VGND VPWR VPWR _3719_/D sky130_fd_sc_hd__nor4_1
X_3649_ _4464_/A _6040_/Q VGND VGND VPWR VPWR _3698_/B sky130_fd_sc_hd__nor2_1
XANTENNA__5135__A1 _3639_/A VGND VGND VPWR VPWR sky130_fd_sc_hd__diode_2
XANTENNA__2786__X _2786_/X VGND VGND VPWR VPWR sky130_fd_sc_hd__diode_2
X_5319_ _6156_/Q _5343_/B VGND VGND VPWR VPWR _5319_/X sky130_fd_sc_hd__xor2_1
Xhold12 hold12/A VGND VGND VPWR VPWR hold12/X sky130_fd_sc_hd__dlygate4sd3_1
Xhold23 hold23/A VGND VGND VPWR VPWR hold23/X sky130_fd_sc_hd__dlygate4sd3_1
XTAP_TAPCELL_ROW_59_915 VGND VPWR sky130_fd_sc_hd__tapvpwrvgnd_1
XANTENNA__4646__B1 _4678_/C1 VGND VGND VPWR VPWR sky130_fd_sc_hd__diode_2
XTAP_TAPCELL_ROW_3_220 VGND VPWR sky130_fd_sc_hd__tapvpwrvgnd_1
Xhold34 hold34/A VGND VGND VPWR VPWR hold34/X sky130_fd_sc_hd__dlygate4sd3_1
Xhold56 hold56/A VGND VGND VPWR VPWR hold56/X sky130_fd_sc_hd__dlygate4sd3_1
Xhold45 hold45/A VGND VGND VPWR VPWR hold45/X sky130_fd_sc_hd__dlygate4sd3_1
Xhold67 hold67/A VGND VGND VPWR VPWR hold67/X sky130_fd_sc_hd__dlygate4sd3_1
Xhold78 hold78/A VGND VGND VPWR VPWR hold78/X sky130_fd_sc_hd__dlygate4sd3_1
Xhold89 hold89/A VGND VGND VPWR VPWR hold89/X sky130_fd_sc_hd__dlygate4sd3_1
XTAP_TAPCELL_ROW_39_672 VGND VPWR sky130_fd_sc_hd__tapvpwrvgnd_1
XFILLER_31_319 VGND VGND VPWR VPWR sky130_fd_sc_hd__fill_1
XFILLER_8_526 VGND VGND VPWR VPWR sky130_fd_sc_hd__decap_6
XANTENNA__5374__A1 _5369_/A VGND VGND VPWR VPWR sky130_fd_sc_hd__diode_2
XANTENNA__3385__B1 _4544_/A VGND VGND VPWR VPWR sky130_fd_sc_hd__diode_2
XANTENNA__4582__C1 _4678_/C1 VGND VGND VPWR VPWR sky130_fd_sc_hd__diode_2
XFILLER_6_49 VGND VGND VPWR VPWR sky130_fd_sc_hd__decap_4
XANTENNA__5126__B2 _5369_/A VGND VGND VPWR VPWR sky130_fd_sc_hd__diode_2
XFILLER_3_253 VGND VGND VPWR VPWR sky130_fd_sc_hd__decap_6
XFILLER_19_121 VGND VGND VPWR VPWR sky130_fd_sc_hd__decap_3
XFILLER_19_198 VGND VGND VPWR VPWR sky130_fd_sc_hd__decap_3
XFILLER_34_124 VGND VGND VPWR VPWR sky130_fd_sc_hd__fill_2
XFILLER_34_146 VGND VGND VPWR VPWR sky130_fd_sc_hd__decap_6
XFILLER_62_499 VGND VGND VPWR VPWR sky130_fd_sc_hd__fill_1
X_2951_ _5613_/Q _3955_/A VGND VGND VPWR VPWR _3956_/S sky130_fd_sc_hd__xor2_1
XTAP_TAPCELL_ROW_17_388 VGND VPWR sky130_fd_sc_hd__tapvpwrvgnd_1
X_5670_ _5685_/CLK _5670_/D fanout316/X VGND VGND VPWR VPWR hold77/A sky130_fd_sc_hd__dfrtp_1
X_2882_ _6089_/Q _2917_/A2 _2886_/B _6093_/Q VGND VGND VPWR VPWR _2882_/X sky130_fd_sc_hd__a22o_1
X_4621_ _5951_/Q _5767_/Q _4623_/S VGND VGND VPWR VPWR _4621_/X sky130_fd_sc_hd__mux2_1
XANTENNA_clkbuf_0_clk_A clk VGND VGND VPWR VPWR sky130_fd_sc_hd__diode_2
XANTENNA__3463__D_N _6129_/D VGND VGND VPWR VPWR sky130_fd_sc_hd__diode_2
X_4552_ _5760_/Q _5174_/A2 _3549_/Y _5863_/D VGND VGND VPWR VPWR _5760_/D sky130_fd_sc_hd__a22o_1
XANTENNA__5117__A1 _3623_/A VGND VGND VPWR VPWR sky130_fd_sc_hd__diode_2
X_4483_ _4481_/Y _4482_/X _4496_/A VGND VGND VPWR VPWR _4483_/Y sky130_fd_sc_hd__a21oi_1
X_3503_ _6121_/D _3517_/B _3492_/X _6142_/D VGND VGND VPWR VPWR _3538_/B sky130_fd_sc_hd__a22o_1
X_3434_ hold26/X _5589_/Q _3434_/S VGND VGND VPWR VPWR _5548_/D sky130_fd_sc_hd__mux2_1
XANTENNA__4738__S _4746_/S VGND VGND VPWR VPWR sky130_fd_sc_hd__diode_2
X_6153_ _6160_/CLK _6153_/D fanout282/X VGND VGND VPWR VPWR _6153_/Q sky130_fd_sc_hd__dfrtp_1
X_3365_ _3365_/A _3365_/B _3365_/C _3365_/D VGND VGND VPWR VPWR _3366_/D sky130_fd_sc_hd__or4_1
XANTENNA__4628__B1 _4740_/B1 VGND VGND VPWR VPWR sky130_fd_sc_hd__diode_2
X_6084_ _6092_/CLK _6084_/D fanout339/X VGND VGND VPWR VPWR _6084_/Q sky130_fd_sc_hd__dfrtp_1
X_3296_ _5983_/Q _5406_/A VGND VGND VPWR VPWR _3343_/A sky130_fd_sc_hd__and2b_1
X_5104_ hold436/X _5406_/A _5127_/B VGND VGND VPWR VPWR _6027_/D sky130_fd_sc_hd__mux2_1
X_5035_ hold447/X _5041_/A2 _5034_/X VGND VGND VPWR VPWR _5963_/D sky130_fd_sc_hd__a21o_1
XANTENNA_fanout183_A _2786_/X VGND VGND VPWR VPWR sky130_fd_sc_hd__diode_2
XANTENNA_fanout350_A fanout351/X VGND VGND VPWR VPWR sky130_fd_sc_hd__diode_2
XANTENNA__5053__A0 _4517_/A VGND VGND VPWR VPWR sky130_fd_sc_hd__diode_2
XTAP_TAPCELL_ROW_36_631 VGND VPWR sky130_fd_sc_hd__tapvpwrvgnd_1
XTAP_TAPCELL_ROW_64_984 VGND VPWR sky130_fd_sc_hd__tapvpwrvgnd_1
XANTENNA__4800__A0 _5472_/Q VGND VGND VPWR VPWR sky130_fd_sc_hd__diode_2
X_5937_ _5965_/CLK _5937_/D fanout302/X VGND VGND VPWR VPWR _5937_/Q sky130_fd_sc_hd__dfrtp_1
XFILLER_34_680 VGND VGND VPWR VPWR sky130_fd_sc_hd__fill_1
XFILLER_41_617 VGND VGND VPWR VPWR sky130_fd_sc_hd__decap_4
X_5868_ _6115_/CLK _5868_/D fanout336/X VGND VGND VPWR VPWR _5868_/Q sky130_fd_sc_hd__dfrtp_1
X_4819_ _3623_/A _4823_/A2 _4824_/B1 hold123/X VGND VGND VPWR VPWR _5855_/D sky130_fd_sc_hd__a22o_1
X_5799_ _6163_/CLK _5799_/D fanout312/X VGND VGND VPWR VPWR _5799_/Q sky130_fd_sc_hd__dfrtp_2
XANTENNA__5108__A1 _5201_/B VGND VGND VPWR VPWR sky130_fd_sc_hd__diode_2
XFILLER_0_223 VGND VGND VPWR VPWR sky130_fd_sc_hd__fill_1
XANTENNA__4619__B1 _4667_/B1 VGND VGND VPWR VPWR sky130_fd_sc_hd__diode_2
XANTENNA_fanout51_X _4750_/A1 VGND VGND VPWR VPWR sky130_fd_sc_hd__diode_2
XFILLER_16_113 VGND VGND VPWR VPWR sky130_fd_sc_hd__fill_2
XFILLER_17_614 VGND VGND VPWR VPWR sky130_fd_sc_hd__fill_2
XFILLER_29_496 VGND VGND VPWR VPWR sky130_fd_sc_hd__decap_8
XANTENNA_clkbuf_leaf_2_clk_A clkload0/A VGND VGND VPWR VPWR sky130_fd_sc_hd__diode_2
XANTENNA__5044__A0 _4404_/A VGND VGND VPWR VPWR sky130_fd_sc_hd__diode_2
XFILLER_17_669 VGND VGND VPWR VPWR sky130_fd_sc_hd__decap_3
XPHY_EDGE_ROW_19_Right_19 VGND VGND VPWR VPWR sky130_fd_sc_hd__decap_3
XANTENNA__4398__A2 _4475_/B VGND VGND VPWR VPWR sky130_fd_sc_hd__diode_2
XANTENNA__3300__B _3905_/A VGND VGND VPWR VPWR sky130_fd_sc_hd__diode_2
XFILLER_12_363 VGND VGND VPWR VPWR sky130_fd_sc_hd__fill_1
XTAP_TAPCELL_ROW_14_358 VGND VPWR sky130_fd_sc_hd__tapvpwrvgnd_1
XFILLER_12_374 VGND VGND VPWR VPWR sky130_fd_sc_hd__fill_2
XFILLER_21_90 VGND VGND VPWR VPWR sky130_fd_sc_hd__fill_1
XPHY_EDGE_ROW_28_Right_28 VGND VGND VPWR VPWR sky130_fd_sc_hd__decap_3
XANTENNA__4858__A0 _2843_/B VGND VGND VPWR VPWR sky130_fd_sc_hd__diode_2
X_3150_ _5520_/Q _3150_/B _3150_/C VGND VGND VPWR VPWR _3150_/X sky130_fd_sc_hd__or3_1
X_3081_ _3081_/A _3081_/B _3081_/C _3081_/D VGND VGND VPWR VPWR _3087_/A sky130_fd_sc_hd__or4_1
XPHY_EDGE_ROW_37_Right_37 VGND VGND VPWR VPWR sky130_fd_sc_hd__decap_3
XFILLER_23_617 VGND VGND VPWR VPWR sky130_fd_sc_hd__decap_6
XFILLER_35_477 VGND VGND VPWR VPWR sky130_fd_sc_hd__fill_1
X_5722_ _5723_/CLK _5722_/D _3183_/B VGND VGND VPWR VPWR _5722_/Q sky130_fd_sc_hd__dfrtp_1
XTAP_TAPCELL_ROW_61_943 VGND VPWR sky130_fd_sc_hd__tapvpwrvgnd_1
X_3983_ _3976_/B _3979_/X _3982_/Y _3980_/Y hold364/X VGND VGND VPWR VPWR _5621_/D
+ sky130_fd_sc_hd__a32o_1
X_2934_ _2934_/A _2934_/B _2842_/B _2844_/C VGND VGND VPWR VPWR _2934_/X sky130_fd_sc_hd__or4bb_1
XFILLER_31_650 VGND VGND VPWR VPWR sky130_fd_sc_hd__decap_4
X_2865_ _6016_/Q _2921_/A2 _2928_/A2 _6000_/Q VGND VGND VPWR VPWR _2868_/A sky130_fd_sc_hd__a22o_1
X_5653_ _5685_/CLK _5653_/D fanout316/X VGND VGND VPWR VPWR _5653_/Q sky130_fd_sc_hd__dfrtp_1
X_4604_ _5949_/Q _4748_/A2 _4684_/B1 _4603_/X VGND VGND VPWR VPWR _4604_/X sky130_fd_sc_hd__a211o_1
XPHY_EDGE_ROW_46_Right_46 VGND VGND VPWR VPWR sky130_fd_sc_hd__decap_3
X_5584_ _5696_/CLK _5584_/D fanout323/X VGND VGND VPWR VPWR _5584_/Q sky130_fd_sc_hd__dfrtp_1
X_2796_ _2793_/X _2794_/X _2795_/X _2785_/X VGND VGND VPWR VPWR _2815_/A sky130_fd_sc_hd__o31a_1
Xhold301 _5776_/Q VGND VGND VPWR VPWR hold301/X sky130_fd_sc_hd__dlygate4sd3_1
X_4535_ _3479_/X _4531_/Y _4534_/X VGND VGND VPWR VPWR _4535_/Y sky130_fd_sc_hd__a21oi_1
Xhold334 _6104_/Q VGND VGND VPWR VPWR hold334/X sky130_fd_sc_hd__dlygate4sd3_1
Xhold312 _6057_/Q VGND VGND VPWR VPWR hold312/X sky130_fd_sc_hd__dlygate4sd3_1
Xhold323 _6169_/Q VGND VGND VPWR VPWR hold323/X sky130_fd_sc_hd__dlygate4sd3_1
XANTENNA__4849__A0 _5467_/Q VGND VGND VPWR VPWR sky130_fd_sc_hd__diode_2
Xhold367 _5689_/Q VGND VGND VPWR VPWR hold367/X sky130_fd_sc_hd__dlygate4sd3_1
Xhold345 _6107_/Q VGND VGND VPWR VPWR hold345/X sky130_fd_sc_hd__dlygate4sd3_1
Xhold378 _5861_/Q VGND VGND VPWR VPWR _4826_/A sky130_fd_sc_hd__dlygate4sd3_1
X_4466_ _4479_/C _4466_/B VGND VGND VPWR VPWR _4466_/X sky130_fd_sc_hd__xor2_1
Xhold356 _5756_/Q VGND VGND VPWR VPWR hold356/X sky130_fd_sc_hd__dlygate4sd3_1
X_3417_ _5613_/Q _3960_/B VGND VGND VPWR VPWR _3961_/A sky130_fd_sc_hd__nand2_4
X_4397_ _3665_/Y _4392_/Y _4396_/X _4357_/X VGND VGND VPWR VPWR _4397_/X sky130_fd_sc_hd__a211o_1
Xhold389 _5862_/Q VGND VGND VPWR VPWR hold389/X sky130_fd_sc_hd__dlygate4sd3_1
XANTENNA__5942__RESET_B fanout306/X VGND VGND VPWR VPWR sky130_fd_sc_hd__diode_2
X_6136_ _6176_/CLK _6136_/D fanout312/X VGND VGND VPWR VPWR _6136_/Q sky130_fd_sc_hd__dfrtp_1
X_3348_ _3365_/B _3365_/C _3365_/D _3348_/D VGND VGND VPWR VPWR _3351_/C sky130_fd_sc_hd__or4_1
X_6067_ _6093_/CLK _6067_/D fanout343/X VGND VGND VPWR VPWR _6067_/Q sky130_fd_sc_hd__dfrtp_1
XPHY_EDGE_ROW_55_Right_55 VGND VGND VPWR VPWR sky130_fd_sc_hd__decap_3
XANTENNA_fanout186_X _3905_/A VGND VGND VPWR VPWR sky130_fd_sc_hd__diode_2
X_3279_ _5447_/A _6033_/Q VGND VGND VPWR VPWR _3355_/C sky130_fd_sc_hd__and2b_1
X_5018_ _4653_/X _5026_/A2 _5026_/B1 _4937_/X VGND VGND VPWR VPWR _5018_/X sky130_fd_sc_hd__a22o_1
XFILLER_26_57 VGND VGND VPWR VPWR sky130_fd_sc_hd__fill_2
XFILLER_26_444 VGND VGND VPWR VPWR sky130_fd_sc_hd__fill_1
XANTENNA__5026__B1 _5026_/B1 VGND VGND VPWR VPWR sky130_fd_sc_hd__diode_2
XANTENNA__4931__S _4973_/S VGND VGND VPWR VPWR sky130_fd_sc_hd__diode_2
XFILLER_13_127 VGND VGND VPWR VPWR sky130_fd_sc_hd__decap_4
XPHY_EDGE_ROW_64_Right_64 VGND VGND VPWR VPWR sky130_fd_sc_hd__decap_3
XTAP_TAPCELL_ROW_11_317 VGND VPWR sky130_fd_sc_hd__tapvpwrvgnd_1
XFILLER_5_337 VGND VGND VPWR VPWR sky130_fd_sc_hd__fill_1
XANTENNA_fanout99_X _5172_/S VGND VGND VPWR VPWR sky130_fd_sc_hd__diode_2
X_5461__2 _5788_/CLK VGND VGND VPWR VPWR _5730_/CLK sky130_fd_sc_hd__inv_2
XFILLER_67_31 VGND VGND VPWR VPWR sky130_fd_sc_hd__decap_3
XFILLER_3_39 VPWR VGND VPWR VGND sky130_ef_sc_hd__decap_12
XPHY_EDGE_ROW_73_Right_73 VGND VGND VPWR VPWR sky130_fd_sc_hd__decap_3
XANTENNA__2866__A2 _2927_/B1 VGND VGND VPWR VPWR sky130_fd_sc_hd__diode_2
XFILLER_76_388 VGND VGND VPWR VPWR sky130_fd_sc_hd__decap_3
XTAP_TAPCELL_ROW_19_417 VGND VPWR sky130_fd_sc_hd__tapvpwrvgnd_1
XTAP_TAPCELL_ROW_67_1020 VGND VPWR sky130_fd_sc_hd__tapvpwrvgnd_1
XFILLER_60_712 VGND VGND VPWR VPWR sky130_fd_sc_hd__fill_1
XFILLER_60_701 VGND VGND VPWR VPWR sky130_fd_sc_hd__fill_1
XANTENNA__4841__S _4863_/S VGND VGND VPWR VPWR sky130_fd_sc_hd__diode_2
XANTENNA__4240__A1 _5767_/Q VGND VGND VPWR VPWR sky130_fd_sc_hd__diode_2
XFILLER_8_197 VGND VGND VPWR VPWR sky130_fd_sc_hd__decap_8
XTAP_TAPCELL_ROW_78_1160 VGND VPWR sky130_fd_sc_hd__tapvpwrvgnd_1
X_4320_ _4320_/A _4320_/B _4320_/C VGND VGND VPWR VPWR _4320_/X sky130_fd_sc_hd__or3_1
X_4251_ _5701_/Q _4329_/A VGND VGND VPWR VPWR _4266_/B sky130_fd_sc_hd__nor2_2
X_3202_ _4970_/A0 _5473_/Q _3203_/S VGND VGND VPWR VPWR _5473_/D sky130_fd_sc_hd__mux2_1
X_4182_ hold176/X _4181_/X _4246_/S VGND VGND VPWR VPWR _5702_/D sky130_fd_sc_hd__mux2_1
X_3133_ _4876_/A _5929_/Q _4735_/S _3131_/X _3132_/X VGND VGND VPWR VPWR _3133_/X
+ sky130_fd_sc_hd__o32a_1
X_3064_ _5605_/Q _5654_/Q VGND VGND VPWR VPWR _3064_/Y sky130_fd_sc_hd__nand2_1
XANTENNA__3806__B2 _3783_/A VGND VGND VPWR VPWR sky130_fd_sc_hd__diode_2
XANTENNA__5008__B1 _5024_/B1 VGND VGND VPWR VPWR sky130_fd_sc_hd__diode_2
XFILLER_51_712 VGND VGND VPWR VPWR sky130_fd_sc_hd__fill_1
XFILLER_50_233 VGND VGND VPWR VPWR sky130_fd_sc_hd__fill_1
XANTENNA_fanout146_A _4876_/Y VGND VGND VPWR VPWR sky130_fd_sc_hd__diode_2
XFILLER_23_458 VGND VGND VPWR VPWR sky130_fd_sc_hd__fill_1
X_3966_ _3967_/B _3966_/B VGND VGND VPWR VPWR _5614_/D sky130_fd_sc_hd__and2_1
X_2917_ _6090_/Q _2917_/A2 _2789_/X _6094_/Q VGND VGND VPWR VPWR _2917_/X sky130_fd_sc_hd__a22o_1
X_5705_ _5792_/CLK _5705_/D fanout296/X VGND VGND VPWR VPWR _5705_/Q sky130_fd_sc_hd__dfrtp_1
X_3897_ _4106_/B _4106_/C _3773_/A VGND VGND VPWR VPWR _3897_/X sky130_fd_sc_hd__a21o_1
XFILLER_12_15 VPWR VGND VPWR VGND sky130_ef_sc_hd__decap_12
X_5636_ _5645_/CLK _5636_/D VGND VGND VPWR VPWR _5636_/Q sky130_fd_sc_hd__dfxtp_1
X_2848_ _5488_/Q _2847_/X _2939_/B VGND VGND VPWR VPWR _2848_/X sky130_fd_sc_hd__mux2_1
XFILLER_12_48 VGND VGND VPWR VPWR sky130_fd_sc_hd__fill_2
X_2779_ hold179/X input3/X _2781_/S VGND VGND VPWR VPWR _5732_/D sky130_fd_sc_hd__mux2_1
X_5567_ _5792_/CLK _5567_/D fanout291/X VGND VGND VPWR VPWR _5567_/Q sky130_fd_sc_hd__dfrtp_2
Xhold153 _6005_/Q VGND VGND VPWR VPWR hold153/X sky130_fd_sc_hd__dlygate4sd3_1
Xhold120 _6074_/Q VGND VGND VPWR VPWR hold120/X sky130_fd_sc_hd__dlygate4sd3_1
XANTENNA_fanout101_X _5043_/A2 VGND VGND VPWR VPWR sky130_fd_sc_hd__diode_2
X_5498_ _6149_/CLK _5498_/D VGND VGND VPWR VPWR hold38/A sky130_fd_sc_hd__dfxtp_1
X_4518_ _4522_/C _4530_/B VGND VGND VPWR VPWR _4519_/B sky130_fd_sc_hd__nand2_1
Xhold142 _5858_/Q VGND VGND VPWR VPWR hold142/X sky130_fd_sc_hd__dlygate4sd3_1
Xhold131 _5677_/Q VGND VGND VPWR VPWR _3088_/B sky130_fd_sc_hd__dlygate4sd3_1
Xhold186 _6011_/Q VGND VGND VPWR VPWR hold186/X sky130_fd_sc_hd__dlygate4sd3_1
Xhold175 _6072_/Q VGND VGND VPWR VPWR hold175/X sky130_fd_sc_hd__dlygate4sd3_1
X_4449_ _4527_/S _4460_/B _4449_/C VGND VGND VPWR VPWR _4449_/X sky130_fd_sc_hd__or3_1
Xhold164 _5513_/Q VGND VGND VPWR VPWR hold164/X sky130_fd_sc_hd__dlygate4sd3_1
Xhold197 _6161_/Q VGND VGND VPWR VPWR hold197/X sky130_fd_sc_hd__dlygate4sd3_1
XANTENNA__3115__B _3138_/B VGND VGND VPWR VPWR sky130_fd_sc_hd__diode_2
XANTENNA__6129__D _6129_/D VGND VGND VPWR VPWR sky130_fd_sc_hd__diode_2
X_6119_ _6120_/CLK _6119_/D fanout313/X VGND VGND VPWR VPWR _6119_/Q sky130_fd_sc_hd__dfrtp_1
XFILLER_73_314 VGND VGND VPWR VPWR sky130_fd_sc_hd__fill_1
XANTENNA_fanout59_A _4747_/A2 VGND VGND VPWR VPWR sky130_fd_sc_hd__diode_2
XFILLER_42_712 VGND VGND VPWR VPWR sky130_fd_sc_hd__fill_1
XTAP_TAPCELL_ROW_44_729 VGND VPWR sky130_fd_sc_hd__tapvpwrvgnd_1
XFILLER_41_244 VPWR VGND VPWR VGND sky130_ef_sc_hd__decap_12
XTAP_TAPCELL_ROW_24_475 VGND VPWR sky130_fd_sc_hd__tapvpwrvgnd_1
XTAP_TAPCELL_ROW_24_486 VGND VPWR sky130_fd_sc_hd__tapvpwrvgnd_1
XFILLER_5_101 VGND VGND VPWR VPWR sky130_fd_sc_hd__decap_8
XANTENNA__5208__D _6128_/D VGND VGND VPWR VPWR sky130_fd_sc_hd__diode_2
XFILLER_5_167 VGND VGND VPWR VPWR sky130_fd_sc_hd__fill_1
XTAP_TAPCELL_ROW_73_1090 VGND VPWR sky130_fd_sc_hd__tapvpwrvgnd_1
XFILLER_1_384 VGND VGND VPWR VPWR sky130_fd_sc_hd__decap_8
XFILLER_76_141 VGND VGND VPWR VPWR sky130_fd_sc_hd__decap_4
XANTENNA__4836__S _4863_/S VGND VGND VPWR VPWR sky130_fd_sc_hd__diode_2
XANTENNA__2864__B _2871_/B VGND VGND VPWR VPWR sky130_fd_sc_hd__diode_2
XFILLER_45_561 VPWR VGND VPWR VGND sky130_ef_sc_hd__decap_12
XFILLER_72_380 VGND VGND VPWR VPWR sky130_fd_sc_hd__fill_2
XFILLER_32_244 VGND VGND VPWR VPWR sky130_fd_sc_hd__fill_2
X_3820_ _5406_/A _3845_/B _3893_/C VGND VGND VPWR VPWR _3820_/X sky130_fd_sc_hd__and3_1
X_3751_ _5901_/Q _3752_/B VGND VGND VPWR VPWR _3879_/S sky130_fd_sc_hd__nor2_2
XFILLER_71_3 VPWR VGND VPWR VGND sky130_ef_sc_hd__decap_12
X_3682_ _4464_/A _5973_/Q _5974_/Q _3656_/A _3681_/Y VGND VGND VPWR VPWR _3682_/Y
+ sky130_fd_sc_hd__a221oi_1
X_5421_ _6171_/Q _5427_/B VGND VGND VPWR VPWR _5422_/B sky130_fd_sc_hd__nor2_1
X_5352_ _3930_/X _5348_/X _5358_/A VGND VGND VPWR VPWR _5357_/B sky130_fd_sc_hd__o21ba_1
X_4303_ _4236_/X _4302_/X _5458_/C VGND VGND VPWR VPWR _4303_/X sky130_fd_sc_hd__mux2_1
X_5283_ hold386/X _5249_/X fanout9/X _5282_/Y VGND VGND VPWR VPWR _6150_/D sky130_fd_sc_hd__a22o_1
X_4234_ _4233_/X _4229_/X _4234_/S VGND VGND VPWR VPWR _4234_/X sky130_fd_sc_hd__mux2_1
X_4165_ _5936_/Q _5760_/Q _4241_/S VGND VGND VPWR VPWR _4165_/X sky130_fd_sc_hd__mux2_1
XANTENNA__4746__S _4746_/S VGND VGND VPWR VPWR sky130_fd_sc_hd__diode_2
X_3116_ _3128_/B _3130_/A _5953_/Q _4876_/A VGND VGND VPWR VPWR _3116_/X sky130_fd_sc_hd__and4b_1
X_4096_ _5866_/Q _3913_/B _3764_/X _3767_/Y VGND VGND VPWR VPWR _4164_/B sky130_fd_sc_hd__o31a_2
X_3047_ _6144_/Q _2965_/X _3042_/X _3046_/X VGND VGND VPWR VPWR _6144_/D sky130_fd_sc_hd__o22a_1
XFILLER_36_550 VGND VGND VPWR VPWR sky130_fd_sc_hd__decap_4
XANTENNA_fanout263_A _4052_/S VGND VGND VPWR VPWR sky130_fd_sc_hd__diode_2
XFILLER_36_594 VGND VGND VPWR VPWR sky130_fd_sc_hd__decap_4
XANTENNA_clkbuf_leaf_42_clk_A clkload1/A VGND VGND VPWR VPWR sky130_fd_sc_hd__diode_2
X_4998_ _4573_/X _5024_/A2 _5024_/B1 _4907_/X VGND VGND VPWR VPWR _4998_/X sky130_fd_sc_hd__a22o_1
X_3949_ _5607_/Q _3564_/A _5353_/A VGND VGND VPWR VPWR _5607_/D sky130_fd_sc_hd__mux2_1
XTAP_TAPCELL_ROW_21_445 VGND VPWR sky130_fd_sc_hd__tapvpwrvgnd_1
X_5619_ _6113_/CLK _5619_/D fanout337/X VGND VGND VPWR VPWR _5619_/Q sky130_fd_sc_hd__dfrtp_1
XFILLER_48_55 VGND VGND VPWR VPWR sky130_fd_sc_hd__decap_3
XFILLER_0_29 VPWR VGND VPWR VGND sky130_ef_sc_hd__decap_12
XTAP_TAPCELL_ROW_29_545 VGND VPWR sky130_fd_sc_hd__tapvpwrvgnd_1
XTAP_TAPCELL_ROW_57_887 VGND VPWR sky130_fd_sc_hd__tapvpwrvgnd_1
XFILLER_15_712 VGND VGND VPWR VPWR sky130_fd_sc_hd__fill_1
XANTENNA__4994__A2 _5038_/A2 VGND VGND VPWR VPWR sky130_fd_sc_hd__diode_2
XTAP_TAPCELL_ROW_57_898 VGND VPWR sky130_fd_sc_hd__tapvpwrvgnd_1
XTAP_TAPCELL_ROW_1_192 VGND VPWR sky130_fd_sc_hd__tapvpwrvgnd_1
XFILLER_14_233 VGND VGND VPWR VPWR sky130_fd_sc_hd__decap_6
XANTENNA__3796__A _6167_/Q VGND VGND VPWR VPWR sky130_fd_sc_hd__diode_2
XFILLER_14_288 VGND VGND VPWR VPWR sky130_fd_sc_hd__fill_1
Xfanout92 _5267_/B VGND VGND VPWR VPWR _5285_/B sky130_fd_sc_hd__clkbuf_2
Xfanout81 _4175_/D VGND VGND VPWR VPWR _3902_/A2 sky130_fd_sc_hd__clkbuf_4
Xfanout70 _4740_/A2 VGND VGND VPWR VPWR _5109_/S sky130_fd_sc_hd__clkbuf_2
XANTENNA__2859__B _2871_/B VGND VGND VPWR VPWR sky130_fd_sc_hd__diode_2
XTAP_TAPCELL_ROW_9_292 VGND VPWR sky130_fd_sc_hd__tapvpwrvgnd_1
XFILLER_2_693 VGND VGND VPWR VPWR sky130_fd_sc_hd__decap_6
XFILLER_80_615 VGND VGND VPWR VPWR sky130_fd_sc_hd__fill_1
X_5970_ clkload3/A _5970_/D fanout272/X VGND VGND VPWR VPWR _5970_/Q sky130_fd_sc_hd__dfrtp_1
XFILLER_25_509 VGND VGND VPWR VPWR sky130_fd_sc_hd__fill_1
X_4921_ hold404/X _4951_/A2 _4920_/X VGND VGND VPWR VPWR _5916_/D sky130_fd_sc_hd__a21o_1
XANTENNA__4985__A2 _5043_/A2 VGND VGND VPWR VPWR sky130_fd_sc_hd__diode_2
XFILLER_45_380 VGND VGND VPWR VPWR sky130_fd_sc_hd__decap_3
X_4852_ _5470_/Q hold264/X _4864_/S VGND VGND VPWR VPWR _5886_/D sky130_fd_sc_hd__mux2_1
XFILLER_20_214 VGND VGND VPWR VPWR sky130_fd_sc_hd__decap_4
X_3803_ _3887_/A _5852_/Q VGND VGND VPWR VPWR _3803_/X sky130_fd_sc_hd__and2_1
X_4783_ _5521_/Q hold266/X _4807_/S VGND VGND VPWR VPWR _5820_/D sky130_fd_sc_hd__mux2_1
X_3734_ _4158_/B _4320_/C VGND VGND VPWR VPWR _3734_/Y sky130_fd_sc_hd__nor2_1
X_3665_ _4354_/S _4386_/S VGND VGND VPWR VPWR _3665_/Y sky130_fd_sc_hd__nor2_1
Xclkload51 _6115_/CLK VGND VGND VPWR VPWR clkload51/Y sky130_fd_sc_hd__inv_6
X_5404_ hold349/X _5441_/B _5359_/Y _5403_/Y VGND VGND VPWR VPWR _6168_/D sky130_fd_sc_hd__a22o_1
Xclkload40 _6176_/CLK VGND VGND VPWR VPWR clkload40/Y sky130_fd_sc_hd__inv_8
XANTENNA__5426__A _5427_/A VGND VGND VPWR VPWR sky130_fd_sc_hd__diode_2
XANTENNA_fanout109_A _4855_/S VGND VGND VPWR VPWR sky130_fd_sc_hd__diode_2
X_3596_ _4444_/B _6054_/Q VGND VGND VPWR VPWR _3717_/A sky130_fd_sc_hd__xor2_1
X_5335_ hold445/X _5341_/B2 _5334_/X VGND VGND VPWR VPWR _6158_/D sky130_fd_sc_hd__a21o_1
X_5266_ _6148_/Q _5267_/B VGND VGND VPWR VPWR _5268_/A sky130_fd_sc_hd__and2_1
X_4217_ _4216_/X _4214_/X _4226_/S VGND VGND VPWR VPWR _4218_/B sky130_fd_sc_hd__mux2_1
X_5197_ _5197_/A _5197_/B VGND VGND VPWR VPWR _5198_/A sky130_fd_sc_hd__nand2_1
X_4148_ _4164_/B _4148_/B _4148_/C _4148_/D VGND VGND VPWR VPWR _4291_/S sky130_fd_sc_hd__or4_2
X_4079_ hold77/A _5674_/D VGND VGND VPWR VPWR _4081_/B sky130_fd_sc_hd__and2_1
XTAP_TAPCELL_ROW_26_504 VGND VPWR sky130_fd_sc_hd__tapvpwrvgnd_1
XTAP_TAPCELL_ROW_54_857 VGND VPWR sky130_fd_sc_hd__tapvpwrvgnd_1
XANTENNA__5100__S _5127_/B VGND VGND VPWR VPWR sky130_fd_sc_hd__diode_2
Xclkload1 clkload1/A VGND VGND VPWR VPWR clkload1/X sky130_fd_sc_hd__clkbuf_8
XFILLER_1_3 VPWR VGND VPWR VGND sky130_ef_sc_hd__decap_12
XFILLER_3_457 VGND VGND VPWR VPWR sky130_fd_sc_hd__fill_2
XANTENNA__2911__A1 _2895_/A VGND VGND VPWR VPWR sky130_fd_sc_hd__diode_2
XANTENNA__2966__Y _3138_/B VGND VGND VPWR VPWR sky130_fd_sc_hd__diode_2
XTAP_TAPCELL_ROW_6_251 VGND VPWR sky130_fd_sc_hd__tapvpwrvgnd_1
Xfanout271 _5475_/Q VGND VGND VPWR VPWR _4964_/A0 sky130_fd_sc_hd__clkbuf_4
XTAP_TAPCELL_ROW_70_1060 VGND VPWR sky130_fd_sc_hd__tapvpwrvgnd_1
XFILLER_59_483 VGND VGND VPWR VPWR sky130_fd_sc_hd__decap_6
Xfanout282 fanout283/X VGND VGND VPWR VPWR fanout282/X sky130_fd_sc_hd__clkbuf_4
Xfanout260 _5669_/Q VGND VGND VPWR VPWR _4014_/A sky130_fd_sc_hd__buf_2
Xfanout293 _3183_/B VGND VGND VPWR VPWR fanout293/X sky130_fd_sc_hd__clkbuf_4
XFILLER_34_317 VGND VGND VPWR VPWR sky130_fd_sc_hd__fill_1
XFILLER_61_169 VGND VGND VPWR VPWR sky130_fd_sc_hd__fill_1
XFILLER_61_147 VGND VGND VPWR VPWR sky130_fd_sc_hd__fill_1
XFILLER_42_361 VGND VGND VPWR VPWR sky130_fd_sc_hd__fill_1
XFILLER_30_567 VGND VGND VPWR VPWR sky130_fd_sc_hd__fill_1
XFILLER_10_280 VPWR VGND VPWR VGND sky130_ef_sc_hd__decap_12
XFILLER_6_251 VGND VGND VPWR VPWR sky130_fd_sc_hd__fill_1
XFILLER_6_295 VPWR VGND VPWR VGND sky130_ef_sc_hd__decap_12
X_3450_ _5588_/Q hold21/X _3451_/S VGND VGND VPWR VPWR _5563_/D sky130_fd_sc_hd__mux2_1
X_3381_ hold190/X _3396_/A _4544_/A _3380_/X VGND VGND VPWR VPWR _5508_/D sky130_fd_sc_hd__a22o_1
X_5120_ hold358/X _3647_/A _5122_/S VGND VGND VPWR VPWR _6043_/D sky130_fd_sc_hd__mux2_1
XFILLER_34_3 VPWR VGND VPWR VGND sky130_ef_sc_hd__decap_12
X_5051_ _4522_/A hold361/X _5051_/S VGND VGND VPWR VPWR _5975_/D sky130_fd_sc_hd__mux2_1
XANTENNA__4655__A1 _5763_/Q VGND VGND VPWR VPWR sky130_fd_sc_hd__diode_2
X_4002_ _5638_/Q _5639_/Q _4005_/S VGND VGND VPWR VPWR _5638_/D sky130_fd_sc_hd__mux2_1
XANTENNA__4407__A1 _4408_/A VGND VGND VPWR VPWR sky130_fd_sc_hd__diode_2
XFILLER_65_486 VGND VGND VPWR VPWR sky130_fd_sc_hd__decap_4
XANTENNA__5080__A1 _5491_/Q VGND VGND VPWR VPWR sky130_fd_sc_hd__diode_2
X_5953_ _6097_/CLK _5953_/D fanout301/X VGND VGND VPWR VPWR _5953_/Q sky130_fd_sc_hd__dfrtp_1
X_4904_ _5487_/Q _4562_/X _4949_/S VGND VGND VPWR VPWR _4904_/X sky130_fd_sc_hd__mux2_1
XANTENNA__5967__RESET_B fanout307/X VGND VGND VPWR VPWR sky130_fd_sc_hd__diode_2
X_5884_ _6088_/CLK _5884_/D fanout340/X VGND VGND VPWR VPWR _5884_/Q sky130_fd_sc_hd__dfrtp_1
XTAP_TAPCELL_ROW_51_816 VGND VPWR sky130_fd_sc_hd__tapvpwrvgnd_1
XFILLER_40_309 VGND VGND VPWR VPWR sky130_fd_sc_hd__fill_1
X_4835_ _5519_/Q hold223/X _4863_/S VGND VGND VPWR VPWR _5869_/D sky130_fd_sc_hd__mux2_1
XTAP_TAPCELL_ROW_31_562 VGND VPWR sky130_fd_sc_hd__tapvpwrvgnd_1
X_4766_ hold181/X _3779_/X _4776_/S VGND VGND VPWR VPWR _5804_/D sky130_fd_sc_hd__mux2_1
X_3717_ _3717_/A _3717_/B _3717_/C _3688_/Y VGND VGND VPWR VPWR _3723_/B sky130_fd_sc_hd__or4b_1
XTAP_TAPCELL_ROW_31_573 VGND VPWR sky130_fd_sc_hd__tapvpwrvgnd_1
X_4697_ hold215/X _4745_/A2 _4696_/X VGND VGND VPWR VPWR _5785_/D sky130_fd_sc_hd__o21a_1
XFILLER_20_15 VPWR VGND VPWR VGND sky130_ef_sc_hd__decap_12
X_3648_ _3648_/A _3648_/B VGND VGND VPWR VPWR _3659_/B sky130_fd_sc_hd__nand2_1
X_3579_ _4447_/B _6101_/Q VGND VGND VPWR VPWR _3708_/D sky130_fd_sc_hd__and2b_1
X_5318_ _5318_/A _5318_/B VGND VGND VPWR VPWR _5318_/Y sky130_fd_sc_hd__nand2_1
XFILLER_0_405 VPWR VGND VPWR VGND sky130_ef_sc_hd__decap_12
XFILLER_0_449 VPWR VGND VPWR VGND sky130_ef_sc_hd__decap_12
Xhold13 hold13/A VGND VGND VPWR VPWR hold13/X sky130_fd_sc_hd__dlygate4sd3_1
XFILLER_29_24 VGND VGND VPWR VPWR sky130_fd_sc_hd__fill_1
XFILLER_75_206 VGND VGND VPWR VPWR sky130_fd_sc_hd__fill_1
XTAP_TAPCELL_ROW_59_916 VGND VPWR sky130_fd_sc_hd__tapvpwrvgnd_1
XANTENNA__4646__A1 _4686_/A1 VGND VGND VPWR VPWR sky130_fd_sc_hd__diode_2
Xhold46 hold46/A VGND VGND VPWR VPWR hold46/X sky130_fd_sc_hd__dlygate4sd3_1
X_5249_ _5310_/A _5285_/B VGND VGND VPWR VPWR _5249_/X sky130_fd_sc_hd__and2b_1
Xhold24 hold24/A VGND VGND VPWR VPWR hold24/X sky130_fd_sc_hd__dlygate4sd3_1
XFILLER_29_57 VGND VGND VPWR VPWR sky130_fd_sc_hd__decap_4
Xhold35 hold35/A VGND VGND VPWR VPWR hold35/X sky130_fd_sc_hd__dlygate4sd3_1
XANTENNA__4110__A3 _4865_/A VGND VGND VPWR VPWR sky130_fd_sc_hd__diode_2
Xhold57 hold57/A VGND VGND VPWR VPWR hold57/X sky130_fd_sc_hd__dlygate4sd3_1
Xhold68 hold68/A VGND VGND VPWR VPWR hold68/X sky130_fd_sc_hd__dlygate4sd3_1
Xhold79 hold79/A VGND VGND VPWR VPWR hold79/X sky130_fd_sc_hd__dlygate4sd3_1
XTAP_TAPCELL_ROW_3_221 VGND VPWR sky130_fd_sc_hd__tapvpwrvgnd_1
XANTENNA__5599__Q _5599_/Q VGND VGND VPWR VPWR sky130_fd_sc_hd__diode_2
XANTENNA__6137__D _6137_/D VGND VGND VPWR VPWR sky130_fd_sc_hd__diode_2
XANTENNA__4934__S _4943_/S VGND VGND VPWR VPWR sky130_fd_sc_hd__diode_2
XTAP_TAPCELL_ROW_39_662 VGND VPWR sky130_fd_sc_hd__tapvpwrvgnd_1
XTAP_TAPCELL_ROW_39_673 VGND VPWR sky130_fd_sc_hd__tapvpwrvgnd_1
XANTENNA__5071__A1 _5520_/Q VGND VGND VPWR VPWR sky130_fd_sc_hd__diode_2
XFILLER_12_589 VGND VGND VPWR VPWR sky130_fd_sc_hd__decap_6
XANTENNA__3793__B _3913_/B VGND VGND VPWR VPWR sky130_fd_sc_hd__diode_2
XANTENNA__4334__A0 _2843_/B VGND VGND VPWR VPWR sky130_fd_sc_hd__diode_2
XANTENNA__3137__B2 _5469_/Q VGND VGND VPWR VPWR sky130_fd_sc_hd__diode_2
XANTENNA__3137__A1 _5094_/A1 VGND VGND VPWR VPWR sky130_fd_sc_hd__diode_2
XANTENNA__2896__B1 _2926_/B1 VGND VGND VPWR VPWR sky130_fd_sc_hd__diode_2
XANTENNA__4637__A1 _5761_/Q VGND VGND VPWR VPWR sky130_fd_sc_hd__diode_2
XANTENNA__4844__S _4864_/S VGND VGND VPWR VPWR sky130_fd_sc_hd__diode_2
XFILLER_35_615 VGND VGND VPWR VPWR sky130_fd_sc_hd__fill_1
XFILLER_34_158 VGND VGND VPWR VPWR sky130_fd_sc_hd__fill_2
XANTENNA__5062__A1 _5427_/A VGND VGND VPWR VPWR sky130_fd_sc_hd__diode_2
X_2950_ _5612_/Q _5609_/Q VGND VGND VPWR VPWR _3208_/A sky130_fd_sc_hd__and2b_1
X_2881_ _2895_/A _6081_/Q _2895_/C _2880_/X VGND VGND VPWR VPWR _2881_/X sky130_fd_sc_hd__a31o_1
XTAP_TAPCELL_ROW_17_389 VGND VPWR sky130_fd_sc_hd__tapvpwrvgnd_1
XFILLER_30_320 VGND VGND VPWR VPWR sky130_fd_sc_hd__fill_1
X_4620_ _5918_/Q _4684_/A2 _4684_/B1 _4619_/X VGND VGND VPWR VPWR _4620_/X sky130_fd_sc_hd__a211o_1
X_4551_ _4978_/C _4551_/B _4551_/C VGND VGND VPWR VPWR _4551_/X sky130_fd_sc_hd__and3_1
XFILLER_7_593 VGND VGND VPWR VPWR sky130_fd_sc_hd__decap_4
X_4482_ _4482_/A _4482_/B _4482_/C VGND VGND VPWR VPWR _4482_/X sky130_fd_sc_hd__or3_1
X_3502_ _3508_/A _3534_/B VGND VGND VPWR VPWR _3502_/Y sky130_fd_sc_hd__xnor2_1
X_3433_ hold14/X _5588_/Q _3434_/S VGND VGND VPWR VPWR _5547_/D sky130_fd_sc_hd__mux2_1
X_6152_ _6160_/CLK _6152_/D fanout310/X VGND VGND VPWR VPWR _6152_/Q sky130_fd_sc_hd__dfrtp_1
XANTENNA__2887__B1 _2926_/B1 VGND VGND VPWR VPWR sky130_fd_sc_hd__diode_2
X_5103_ hold422/X _5397_/A _5127_/B VGND VGND VPWR VPWR _6026_/D sky130_fd_sc_hd__mux2_1
X_3364_ _3364_/A _3364_/B _3364_/C _3364_/D VGND VGND VPWR VPWR _3366_/C sky130_fd_sc_hd__or4_1
X_6083_ _6091_/CLK _6083_/D fanout343/X VGND VGND VPWR VPWR _6083_/Q sky130_fd_sc_hd__dfrtp_1
X_3295_ _3295_/A _3295_/B _3295_/C _3295_/D VGND VGND VPWR VPWR _3295_/X sky130_fd_sc_hd__or4_1
X_5034_ _4717_/X _4979_/A _4979_/B _4961_/X VGND VGND VPWR VPWR _5034_/X sky130_fd_sc_hd__a22o_1
XPHY_EDGE_ROW_69_Left_150 VGND VGND VPWR VPWR sky130_fd_sc_hd__decap_3
XTAP_TAPCELL_ROW_36_632 VGND VPWR sky130_fd_sc_hd__tapvpwrvgnd_1
XANTENNA_fanout343_A fanout351/X VGND VGND VPWR VPWR sky130_fd_sc_hd__diode_2
X_5936_ _5967_/CLK _5936_/D fanout307/X VGND VGND VPWR VPWR _5936_/Q sky130_fd_sc_hd__dfrtp_1
XTAP_TAPCELL_ROW_64_985 VGND VPWR sky130_fd_sc_hd__tapvpwrvgnd_1
XTAP_TAPCELL_ROW_64_974 VGND VPWR sky130_fd_sc_hd__tapvpwrvgnd_1
XFILLER_13_309 VPWR VGND VPWR VGND sky130_ef_sc_hd__decap_12
XFILLER_25_169 VGND VGND VPWR VPWR sky130_fd_sc_hd__fill_2
XANTENNA__2811__B1 _2886_/B VGND VGND VPWR VPWR sky130_fd_sc_hd__diode_2
XFILLER_40_139 VGND VGND VPWR VPWR sky130_fd_sc_hd__fill_1
XANTENNA_fanout131_X _4810_/S VGND VGND VPWR VPWR sky130_fd_sc_hd__diode_2
X_5867_ _6115_/CLK _5867_/D fanout335/X VGND VGND VPWR VPWR _5867_/Q sky130_fd_sc_hd__dfrtp_1
XFILLER_21_397 VGND VGND VPWR VPWR sky130_fd_sc_hd__decap_4
X_4818_ _2744_/A _4823_/A2 _4824_/B1 hold119/X VGND VGND VPWR VPWR _5854_/D sky130_fd_sc_hd__a22o_1
XFILLER_31_25 VGND VGND VPWR VPWR sky130_fd_sc_hd__decap_4
X_5798_ _6163_/CLK _5798_/D fanout325/X VGND VGND VPWR VPWR _5798_/Q sky130_fd_sc_hd__dfrtp_1
XANTENNA__4564__B1 _4684_/B1 VGND VGND VPWR VPWR sky130_fd_sc_hd__diode_2
X_4749_ _5767_/Q _5967_/Q _4751_/S VGND VGND VPWR VPWR _4749_/X sky130_fd_sc_hd__mux2_1
XANTENNA__4316__B1 _5719_/Q VGND VGND VPWR VPWR sky130_fd_sc_hd__diode_2
XANTENNA__2797__X _2797_/X VGND VGND VPWR VPWR sky130_fd_sc_hd__diode_2
XANTENNA__2893__A3 _2895_/C VGND VGND VPWR VPWR sky130_fd_sc_hd__diode_2
XFILLER_56_66 VGND VGND VPWR VPWR sky130_fd_sc_hd__decap_8
XFILLER_44_423 VGND VGND VPWR VPWR sky130_fd_sc_hd__decap_6
XANTENNA_fanout44_X _4243_/S VGND VGND VPWR VPWR sky130_fd_sc_hd__diode_2
XFILLER_25_670 VGND VGND VPWR VPWR sky130_fd_sc_hd__fill_2
XFILLER_25_681 VGND VGND VPWR VPWR sky130_fd_sc_hd__fill_1
XANTENNA__2802__B1 _2797_/X VGND VGND VPWR VPWR sky130_fd_sc_hd__diode_2
XTAP_TAPCELL_ROW_14_359 VGND VPWR sky130_fd_sc_hd__tapvpwrvgnd_1
XFILLER_40_684 VGND VGND VPWR VPWR sky130_fd_sc_hd__fill_1
XANTENNA__4412__B _4475_/B VGND VGND VPWR VPWR sky130_fd_sc_hd__diode_2
XANTENNA__4555__B1 _3548_/Y VGND VGND VPWR VPWR sky130_fd_sc_hd__diode_2
XANTENNA__4839__S _4863_/S VGND VGND VPWR VPWR sky130_fd_sc_hd__diode_2
XFILLER_67_515 VGND VGND VPWR VPWR sky130_fd_sc_hd__fill_1
XFILLER_67_559 VGND VGND VPWR VPWR sky130_fd_sc_hd__fill_1
X_3080_ _5593_/Q _5679_/Q VGND VGND VPWR VPWR _3081_/D sky130_fd_sc_hd__xor2_1
XFILLER_39_228 VGND VGND VPWR VPWR sky130_fd_sc_hd__decap_4
XANTENNA__3833__A2 _4865_/A VGND VGND VPWR VPWR sky130_fd_sc_hd__diode_2
XFILLER_62_253 VGND VGND VPWR VPWR sky130_fd_sc_hd__fill_1
XANTENNA__3046__B1 _3138_/B VGND VGND VPWR VPWR sky130_fd_sc_hd__diode_2
XFILLER_50_404 VGND VGND VPWR VPWR sky130_fd_sc_hd__fill_1
XFILLER_23_607 VGND VGND VPWR VPWR sky130_fd_sc_hd__decap_8
X_3982_ _5648_/Q _5621_/Q VGND VGND VPWR VPWR _3982_/Y sky130_fd_sc_hd__nor2_1
X_5721_ _5792_/CLK _5721_/D fanout296/X VGND VGND VPWR VPWR _5721_/Q sky130_fd_sc_hd__dfrtp_2
XANTENNA__4794__A0 _5494_/Q VGND VGND VPWR VPWR sky130_fd_sc_hd__diode_2
XTAP_TAPCELL_ROW_61_944 VGND VPWR sky130_fd_sc_hd__tapvpwrvgnd_1
X_2933_ _2784_/X _2930_/X _2932_/X VGND VGND VPWR VPWR _2933_/X sky130_fd_sc_hd__a21o_1
X_2864_ _2864_/A _2871_/B _2871_/C _6020_/Q VGND VGND VPWR VPWR _2864_/X sky130_fd_sc_hd__and4_1
X_5652_ _5685_/CLK _5652_/D fanout316/X VGND VGND VPWR VPWR _5652_/Q sky130_fd_sc_hd__dfrtp_1
X_2795_ _6007_/Q _2783_/B _2921_/B1 _5995_/Q _2790_/X VGND VGND VPWR VPWR _2795_/X
+ sky130_fd_sc_hd__a221o_1
X_4603_ _5916_/Q _4684_/A2 _4667_/B1 _4602_/X VGND VGND VPWR VPWR _4603_/X sky130_fd_sc_hd__a22o_1
X_5583_ _6120_/CLK _5583_/D fanout313/X VGND VGND VPWR VPWR _5583_/Q sky130_fd_sc_hd__dfrtp_1
XANTENNA__4546__B1 _4829_/B VGND VGND VPWR VPWR sky130_fd_sc_hd__diode_2
XTAP_TAPCELL_ROW_41_690 VGND VPWR sky130_fd_sc_hd__tapvpwrvgnd_1
X_4534_ _4496_/A _4532_/X _4533_/Y _4436_/S VGND VGND VPWR VPWR _4534_/X sky130_fd_sc_hd__a31o_1
Xhold302 _5870_/Q VGND VGND VPWR VPWR hold302/X sky130_fd_sc_hd__dlygate4sd3_1
Xhold313 _6013_/Q VGND VGND VPWR VPWR hold313/X sky130_fd_sc_hd__dlygate4sd3_1
Xhold335 _5873_/Q VGND VGND VPWR VPWR hold335/X sky130_fd_sc_hd__dlygate4sd3_1
Xhold324 _5059_/X VGND VGND VPWR VPWR _5983_/D sky130_fd_sc_hd__dlygate4sd3_1
Xhold346 _5720_/Q VGND VGND VPWR VPWR hold346/X sky130_fd_sc_hd__dlygate4sd3_1
Xhold368 _5724_/Q VGND VGND VPWR VPWR hold368/X sky130_fd_sc_hd__dlygate4sd3_1
Xhold357 _5625_/Q VGND VGND VPWR VPWR _3056_/B sky130_fd_sc_hd__dlygate4sd3_1
X_4465_ _4452_/A _4399_/B _4454_/Y VGND VGND VPWR VPWR _4466_/B sky130_fd_sc_hd__o21ai_1
Xhold379 _5977_/Q VGND VGND VPWR VPWR hold379/X sky130_fd_sc_hd__dlygate4sd3_1
X_3416_ hold19/X _5642_/Q _3416_/S VGND VGND VPWR VPWR _5532_/D sky130_fd_sc_hd__mux2_1
X_4396_ _4354_/S _4404_/B _4394_/Y _4395_/Y _4386_/S VGND VGND VPWR VPWR _4396_/X
+ sky130_fd_sc_hd__a32o_1
X_6135_ _6176_/CLK _6135_/D fanout312/X VGND VGND VPWR VPWR _6135_/Q sky130_fd_sc_hd__dfrtp_1
X_3347_ _3364_/A _3364_/B _3365_/A _3364_/D VGND VGND VPWR VPWR _3348_/D sky130_fd_sc_hd__or4_1
X_6066_ _6115_/CLK _6066_/D fanout336/X VGND VGND VPWR VPWR _6066_/Q sky130_fd_sc_hd__dfrtp_1
X_5017_ hold400/X _5027_/A2 _5016_/X VGND VGND VPWR VPWR _5954_/D sky130_fd_sc_hd__a21o_1
X_3278_ _6023_/Q _5377_/A VGND VGND VPWR VPWR _3280_/C sky130_fd_sc_hd__and2b_1
XTAP_TAPCELL_ROW_49_790 VGND VPWR sky130_fd_sc_hd__tapvpwrvgnd_1
XANTENNA__4785__A0 _5523_/Q VGND VGND VPWR VPWR sky130_fd_sc_hd__diode_2
X_5919_ _5952_/CLK _5919_/D fanout330/X VGND VGND VPWR VPWR _5919_/Q sky130_fd_sc_hd__dfrtp_1
XTAP_TAPCELL_ROW_11_318 VGND VPWR sky130_fd_sc_hd__tapvpwrvgnd_1
XFILLER_21_194 VGND VGND VPWR VPWR sky130_fd_sc_hd__fill_1
XFILLER_67_54 VGND VGND VPWR VPWR sky130_fd_sc_hd__fill_2
XFILLER_49_559 VGND VGND VPWR VPWR sky130_fd_sc_hd__fill_1
XTAP_TAPCELL_ROW_19_418 VGND VPWR sky130_fd_sc_hd__tapvpwrvgnd_1
XTAP_TAPCELL_ROW_67_1021 VGND VPWR sky130_fd_sc_hd__tapvpwrvgnd_1
XFILLER_17_434 VGND VGND VPWR VPWR sky130_fd_sc_hd__fill_1
XFILLER_44_275 VGND VGND VPWR VPWR sky130_fd_sc_hd__fill_2
XFILLER_13_673 VGND VGND VPWR VPWR sky130_fd_sc_hd__decap_4
XFILLER_13_684 VGND VGND VPWR VPWR sky130_fd_sc_hd__fill_2
XFILLER_8_143 VGND VGND VPWR VPWR sky130_fd_sc_hd__fill_2
XANTENNA__3200__A0 _4964_/A0 VGND VGND VPWR VPWR sky130_fd_sc_hd__diode_2
XTAP_TAPCELL_ROW_78_1161 VGND VPWR sky130_fd_sc_hd__tapvpwrvgnd_1
XTAP_TAPCELL_ROW_78_1150 VGND VPWR sky130_fd_sc_hd__tapvpwrvgnd_1
X_4250_ _4250_/A _4250_/B VGND VGND VPWR VPWR _4250_/Y sky130_fd_sc_hd__nor2_2
X_4181_ _4181_/A _4181_/B VGND VGND VPWR VPWR _4181_/X sky130_fd_sc_hd__or2_1
X_3201_ _4967_/A0 _5472_/Q _3203_/S VGND VGND VPWR VPWR _5472_/D sky130_fd_sc_hd__mux2_1
XANTENNA__4700__B1 _4243_/S VGND VGND VPWR VPWR sky130_fd_sc_hd__diode_2
X_3132_ _5938_/Q _2980_/Y _3144_/B VGND VGND VPWR VPWR _3132_/X sky130_fd_sc_hd__a21o_1
X_3063_ _5605_/Q _5654_/Q VGND VGND VPWR VPWR _3063_/X sky130_fd_sc_hd__or2_1
XTAP_TAPCELL_ROW_46_760 VGND VPWR sky130_fd_sc_hd__tapvpwrvgnd_1
X_3965_ _4070_/S _3976_/A VGND VGND VPWR VPWR _3966_/B sky130_fd_sc_hd__or2_1
X_2916_ _6074_/Q _2916_/B VGND VGND VPWR VPWR _2916_/X sky130_fd_sc_hd__and2_1
X_5704_ _5723_/CLK _5704_/D fanout293/X VGND VGND VPWR VPWR _5704_/Q sky130_fd_sc_hd__dfrtp_1
X_3896_ _5579_/Q _3896_/B VGND VGND VPWR VPWR _3896_/Y sky130_fd_sc_hd__nor2_1
XANTENNA_fanout139_A _5038_/A2 VGND VGND VPWR VPWR sky130_fd_sc_hd__diode_2
XANTENNA__2793__A2 _2910_/B VGND VGND VPWR VPWR sky130_fd_sc_hd__diode_2
X_2847_ _2724_/Y _2937_/B _2845_/X _2846_/X VGND VGND VPWR VPWR _2847_/X sky130_fd_sc_hd__a2bb2o_1
XFILLER_12_27 VGND VGND VPWR VPWR sky130_fd_sc_hd__fill_1
X_5635_ _5635_/CLK _5635_/D VGND VGND VPWR VPWR _5635_/Q sky130_fd_sc_hd__dfxtp_1
X_2778_ hold191/X input4/X _2781_/S VGND VGND VPWR VPWR _5733_/D sky130_fd_sc_hd__mux2_1
XANTENNA_fanout306_A fanout309/X VGND VGND VPWR VPWR sky130_fd_sc_hd__diode_2
XANTENNA_clkbuf_2_1__f_clk_A clkbuf_0_clk/X VGND VGND VPWR VPWR sky130_fd_sc_hd__diode_2
X_5566_ _5792_/CLK _5566_/D fanout291/X VGND VGND VPWR VPWR _5566_/Q sky130_fd_sc_hd__dfrtp_4
Xhold110 _5801_/Q VGND VGND VPWR VPWR hold110/X sky130_fd_sc_hd__dlygate4sd3_1
XANTENNA__5192__B1 _4539_/X VGND VGND VPWR VPWR sky130_fd_sc_hd__diode_2
Xhold143 _5831_/Q VGND VGND VPWR VPWR hold143/X sky130_fd_sc_hd__dlygate4sd3_1
XANTENNA__2788__A _2864_/A VGND VGND VPWR VPWR sky130_fd_sc_hd__diode_2
X_5497_ _5645_/CLK _5497_/D VGND VGND VPWR VPWR hold71/A sky130_fd_sc_hd__dfxtp_1
X_4517_ _4517_/A _4530_/B VGND VGND VPWR VPWR _4517_/Y sky130_fd_sc_hd__nor2_1
XANTENNA_clkbuf_leaf_1_clk_A clkload0/A VGND VGND VPWR VPWR sky130_fd_sc_hd__diode_2
Xhold132 _5810_/Q VGND VGND VPWR VPWR hold132/X sky130_fd_sc_hd__dlygate4sd3_1
Xhold121 _5808_/Q VGND VGND VPWR VPWR hold121/X sky130_fd_sc_hd__dlygate4sd3_1
Xhold176 _5702_/Q VGND VGND VPWR VPWR hold176/X sky130_fd_sc_hd__dlygate4sd3_1
Xhold154 _6084_/Q VGND VGND VPWR VPWR hold154/X sky130_fd_sc_hd__dlygate4sd3_1
Xhold165 _5865_/Q VGND VGND VPWR VPWR _4830_/A sky130_fd_sc_hd__dlygate4sd3_1
X_4448_ _4447_/A _4447_/C _4444_/B VGND VGND VPWR VPWR _4449_/C sky130_fd_sc_hd__a21oi_1
Xhold187 _6083_/Q VGND VGND VPWR VPWR hold187/X sky130_fd_sc_hd__dlygate4sd3_1
Xhold198 _6067_/Q VGND VGND VPWR VPWR hold198/X sky130_fd_sc_hd__dlygate4sd3_1
X_4379_ _4829_/C _4380_/B VGND VGND VPWR VPWR _4394_/B sky130_fd_sc_hd__or2_1
X_6118_ _6120_/CLK _6118_/D fanout319/X VGND VGND VPWR VPWR _6118_/Q sky130_fd_sc_hd__dfrtp_1
XANTENNA__5103__S _5127_/B VGND VGND VPWR VPWR sky130_fd_sc_hd__diode_2
XFILLER_37_35 VGND VGND VPWR VPWR sky130_fd_sc_hd__fill_1
X_6049_ _6110_/CLK _6049_/D fanout301/X VGND VGND VPWR VPWR _6049_/Q sky130_fd_sc_hd__dfrtp_1
XFILLER_26_253 VPWR VGND VPWR VGND sky130_ef_sc_hd__decap_12
XFILLER_41_212 VPWR VGND VPWR VGND sky130_ef_sc_hd__decap_12
XFILLER_41_256 VGND VGND VPWR VPWR sky130_fd_sc_hd__decap_8
XTAP_TAPCELL_ROW_24_476 VGND VPWR sky130_fd_sc_hd__tapvpwrvgnd_1
XFILLER_41_278 VGND VGND VPWR VPWR sky130_fd_sc_hd__fill_2
XFILLER_10_643 VGND VGND VPWR VPWR sky130_fd_sc_hd__fill_1
XTAP_TAPCELL_ROW_73_1091 VGND VPWR sky130_fd_sc_hd__tapvpwrvgnd_1
XFILLER_76_153 VGND VGND VPWR VPWR sky130_fd_sc_hd__decap_4
XFILLER_64_359 VGND VGND VPWR VPWR sky130_fd_sc_hd__decap_4
XANTENNA__2864__C _2871_/C VGND VGND VPWR VPWR sky130_fd_sc_hd__diode_2
XANTENNA__4852__S _4864_/S VGND VGND VPWR VPWR sky130_fd_sc_hd__diode_2
XFILLER_45_573 VGND VGND VPWR VPWR sky130_fd_sc_hd__fill_2
XANTENNA__4749__A0 _5767_/Q VGND VGND VPWR VPWR sky130_fd_sc_hd__diode_2
X_3750_ _3745_/X _3746_/X _3748_/Y VGND VGND VPWR VPWR _3750_/X sky130_fd_sc_hd__o21a_1
XFILLER_9_430 VGND VGND VPWR VPWR sky130_fd_sc_hd__fill_1
X_3681_ _4464_/A _5973_/Q _4873_/A _4873_/B VGND VGND VPWR VPWR _3681_/Y sky130_fd_sc_hd__o211ai_1
XFILLER_64_3 VGND VGND VPWR VPWR sky130_fd_sc_hd__fill_2
X_5420_ _5416_/A _5416_/B _5430_/A VGND VGND VPWR VPWR _5420_/X sky130_fd_sc_hd__a21o_1
X_5351_ _3483_/A _5197_/B _4344_/A VGND VGND VPWR VPWR _5358_/A sky130_fd_sc_hd__a21oi_1
X_4302_ _5712_/Q _4308_/A2 _4250_/Y _4301_/X VGND VGND VPWR VPWR _4302_/X sky130_fd_sc_hd__a22o_1
X_5282_ _5287_/B _5282_/B VGND VGND VPWR VPWR _5282_/Y sky130_fd_sc_hd__xnor2_1
X_4233_ _5942_/Q _4177_/C _4176_/C _5909_/Q VGND VGND VPWR VPWR _4233_/X sky130_fd_sc_hd__a22o_1
X_4164_ _4164_/A _4164_/B VGND VGND VPWR VPWR _4246_/S sky130_fd_sc_hd__nor2_4
X_4095_ _4247_/A _4266_/A VGND VGND VPWR VPWR _4329_/B sky130_fd_sc_hd__or2_1
X_3115_ hold49/X _3138_/B VGND VGND VPWR VPWR _3126_/A sky130_fd_sc_hd__nand2_1
X_3046_ _2993_/X _3044_/X _3045_/X _3138_/B VGND VGND VPWR VPWR _3046_/X sky130_fd_sc_hd__a31o_1
XANTENNA_fanout256_A _5728_/Q VGND VGND VPWR VPWR sky130_fd_sc_hd__diode_2
X_4997_ _5944_/Q _5027_/A2 _4996_/X VGND VGND VPWR VPWR _5944_/D sky130_fd_sc_hd__a21o_1
XFILLER_23_15 VGND VGND VPWR VPWR sky130_fd_sc_hd__decap_4
X_3948_ hold455/X _3536_/Y _5353_/A VGND VGND VPWR VPWR _5606_/D sky130_fd_sc_hd__mux2_1
XTAP_TAPCELL_ROW_21_446 VGND VPWR sky130_fd_sc_hd__tapvpwrvgnd_1
X_3879_ _5812_/Q _5513_/Q _3879_/S VGND VGND VPWR VPWR _3879_/X sky130_fd_sc_hd__mux2_1
XANTENNA_fanout309_X fanout309/X VGND VGND VPWR VPWR sky130_fd_sc_hd__diode_2
X_5618_ _6113_/CLK _5618_/D fanout337/X VGND VGND VPWR VPWR _5618_/Q sky130_fd_sc_hd__dfstp_1
XFILLER_3_617 VGND VGND VPWR VPWR sky130_fd_sc_hd__fill_1
X_5549_ _5696_/CLK _5549_/D VGND VGND VPWR VPWR hold37/A sky130_fd_sc_hd__dfxtp_1
XANTENNA__4002__S _4005_/S VGND VGND VPWR VPWR sky130_fd_sc_hd__diode_2
XANTENNA__4140__A1 _4164_/B VGND VGND VPWR VPWR sky130_fd_sc_hd__diode_2
XANTENNA_fanout71_A _4166_/C VGND VGND VPWR VPWR sky130_fd_sc_hd__diode_2
XFILLER_73_101 VGND VGND VPWR VPWR sky130_fd_sc_hd__fill_2
XANTENNA__4691__A2 _4747_/A2 VGND VGND VPWR VPWR sky130_fd_sc_hd__diode_2
XFILLER_58_197 VGND VGND VPWR VPWR sky130_fd_sc_hd__decap_6
XTAP_TAPCELL_ROW_29_546 VGND VPWR sky130_fd_sc_hd__tapvpwrvgnd_1
XFILLER_64_33 VGND VGND VPWR VPWR sky130_fd_sc_hd__fill_1
XTAP_TAPCELL_ROW_57_888 VGND VPWR sky130_fd_sc_hd__tapvpwrvgnd_1
XTAP_TAPCELL_ROW_1_193 VGND VPWR sky130_fd_sc_hd__tapvpwrvgnd_1
XANTENNA__3403__A0 _2934_/B VGND VGND VPWR VPWR sky130_fd_sc_hd__diode_2
XANTENNA__4600__C1 _4720_/C1 VGND VGND VPWR VPWR sky130_fd_sc_hd__diode_2
Xfanout71 _4166_/C VGND VGND VPWR VPWR _4748_/A2 sky130_fd_sc_hd__clkbuf_4
Xfanout60 _5055_/S VGND VGND VPWR VPWR _4747_/A2 sky130_fd_sc_hd__clkbuf_4
Xfanout82 _3353_/X VGND VGND VPWR VPWR _4175_/D sky130_fd_sc_hd__buf_2
Xfanout93 _5248_/Y VGND VGND VPWR VPWR _5267_/B sky130_fd_sc_hd__buf_1
XFILLER_13_70 VGND VGND VPWR VPWR sky130_fd_sc_hd__decap_3
XPHY_EDGE_ROW_23_Left_104 VGND VGND VPWR VPWR sky130_fd_sc_hd__decap_3
XTAP_TAPCELL_ROW_75_1120 VGND VPWR sky130_fd_sc_hd__tapvpwrvgnd_1
XANTENNA__2859__C _2871_/C VGND VGND VPWR VPWR sky130_fd_sc_hd__diode_2
XANTENNA__4847__S _4855_/S VGND VGND VPWR VPWR sky130_fd_sc_hd__diode_2
XTAP_TAPCELL_ROW_9_293 VGND VPWR sky130_fd_sc_hd__tapvpwrvgnd_1
XANTENNA__4148__A _4164_/B VGND VGND VPWR VPWR sky130_fd_sc_hd__diode_2
XPHY_EDGE_ROW_32_Left_113 VGND VGND VPWR VPWR sky130_fd_sc_hd__decap_3
XFILLER_80_627 VGND VGND VPWR VPWR sky130_fd_sc_hd__fill_1
X_4920_ _4606_/X _4950_/A2 _4950_/B1 _4919_/X VGND VGND VPWR VPWR _4920_/X sky130_fd_sc_hd__a22o_1
X_4851_ _5469_/Q hold306/X _4855_/S VGND VGND VPWR VPWR _5885_/D sky130_fd_sc_hd__mux2_1
XANTENNA__3198__S _3203_/S VGND VGND VPWR VPWR sky130_fd_sc_hd__diode_2
X_3802_ _5571_/Q _3826_/S _3801_/X VGND VGND VPWR VPWR _5571_/D sky130_fd_sc_hd__o21ba_1
XFILLER_60_384 VGND VGND VPWR VPWR sky130_fd_sc_hd__fill_2
X_4782_ _5520_/Q hold168/X _4805_/S VGND VGND VPWR VPWR _5819_/D sky130_fd_sc_hd__mux2_1
X_3733_ _5700_/Q _4247_/A VGND VGND VPWR VPWR _4320_/C sky130_fd_sc_hd__nand2_1
XFILLER_9_260 VPWR VGND VPWR VGND sky130_ef_sc_hd__decap_12
XANTENNA__3945__A1 _3548_/Y VGND VGND VPWR VPWR sky130_fd_sc_hd__diode_2
X_3664_ _4436_/S VGND VGND VPWR VPWR _4527_/S sky130_fd_sc_hd__inv_2
XPHY_EDGE_ROW_41_Left_122 VGND VGND VPWR VPWR sky130_fd_sc_hd__decap_3
Xclkload41 _6142_/CLK VGND VGND VPWR VPWR clkload41/Y sky130_fd_sc_hd__clkinv_8
Xclkload52 _6131_/CLK VGND VGND VPWR VPWR clkload52/Y sky130_fd_sc_hd__clkinv_8
X_5403_ _5403_/A _5409_/B VGND VGND VPWR VPWR _5403_/Y sky130_fd_sc_hd__nor2_1
Xclkload30 _5697_/CLK VGND VGND VPWR VPWR clkload30/Y sky130_fd_sc_hd__clkinvlp_4
X_3595_ _5740_/Q _6051_/Q VGND VGND VPWR VPWR _3598_/B sky130_fd_sc_hd__xor2_1
X_5334_ _5329_/X _5330_/Y _5332_/Y _5333_/Y _5327_/C VGND VGND VPWR VPWR _5334_/X
+ sky130_fd_sc_hd__o311a_1
X_5265_ hold394/X _5252_/X _5264_/X fanout9/X VGND VGND VPWR VPWR _6147_/D sky130_fd_sc_hd__a22o_1
X_4216_ _4215_/X _4211_/X _4234_/S VGND VGND VPWR VPWR _4216_/X sky130_fd_sc_hd__mux2_1
X_5196_ _4346_/X _5196_/B VGND VGND VPWR VPWR _5230_/B sky130_fd_sc_hd__nand2b_1
X_4147_ _4319_/A _4148_/D VGND VGND VPWR VPWR _4258_/A sky130_fd_sc_hd__nor2_1
XPHY_EDGE_ROW_50_Left_131 VGND VGND VPWR VPWR sky130_fd_sc_hd__decap_3
XFILLER_18_15 VPWR VGND VPWR VGND sky130_ef_sc_hd__decap_12
XFILLER_18_48 VGND VGND VPWR VPWR sky130_fd_sc_hd__decap_3
X_4078_ _4078_/A _5674_/D VGND VGND VPWR VPWR _4080_/A sky130_fd_sc_hd__nor2_1
XFILLER_43_307 VGND VGND VPWR VPWR sky130_fd_sc_hd__fill_1
XFILLER_70_115 VGND VGND VPWR VPWR sky130_fd_sc_hd__fill_2
X_3029_ _4618_/S _4682_/S _4970_/A0 VGND VGND VPWR VPWR _3029_/Y sky130_fd_sc_hd__nor3b_1
XTAP_TAPCELL_ROW_26_505 VGND VPWR sky130_fd_sc_hd__tapvpwrvgnd_1
XANTENNA_fanout259_X _2824_/C VGND VGND VPWR VPWR sky130_fd_sc_hd__diode_2
XFILLER_70_137 VGND VGND VPWR VPWR sky130_fd_sc_hd__decap_3
XTAP_TAPCELL_ROW_54_858 VGND VPWR sky130_fd_sc_hd__tapvpwrvgnd_1
XFILLER_24_587 VGND VGND VPWR VPWR sky130_fd_sc_hd__fill_1
XFILLER_11_237 VGND VGND VPWR VPWR sky130_fd_sc_hd__decap_8
Xclkload2 clkload2/A VGND VGND VPWR VPWR clkload2/X sky130_fd_sc_hd__clkbuf_8
XANTENNA__3936__A1 _3548_/Y VGND VGND VPWR VPWR sky130_fd_sc_hd__diode_2
XANTENNA__4521__A _4522_/C VGND VGND VPWR VPWR sky130_fd_sc_hd__diode_2
XFILLER_59_11 VGND VGND VPWR VPWR sky130_fd_sc_hd__decap_3
XFILLER_59_88 VGND VGND VPWR VPWR sky130_fd_sc_hd__decap_4
XTAP_TAPCELL_ROW_6_252 VGND VPWR sky130_fd_sc_hd__tapvpwrvgnd_1
Xfanout250 _5740_/Q VGND VGND VPWR VPWR _4404_/A sky130_fd_sc_hd__clkbuf_4
XTAP_TAPCELL_ROW_70_1061 VGND VPWR sky130_fd_sc_hd__tapvpwrvgnd_1
XTAP_TAPCELL_ROW_70_1050 VGND VPWR sky130_fd_sc_hd__tapvpwrvgnd_1
XANTENNA_fanout74_X _4740_/A2 VGND VGND VPWR VPWR sky130_fd_sc_hd__diode_2
Xfanout272 fanout276/X VGND VGND VPWR VPWR fanout272/X sky130_fd_sc_hd__clkbuf_4
Xfanout283 fanout287/X VGND VGND VPWR VPWR fanout283/X sky130_fd_sc_hd__clkbuf_4
Xfanout261 _5615_/Q VGND VGND VPWR VPWR _4074_/S1 sky130_fd_sc_hd__buf_2
Xfanout294 fanout298/X VGND VGND VPWR VPWR _3183_/B sky130_fd_sc_hd__clkbuf_4
XFILLER_19_337 VPWR VGND VPWR VGND sky130_ef_sc_hd__decap_12
XFILLER_10_292 VPWR VGND VPWR VGND sky130_ef_sc_hd__decap_12
X_3380_ _5983_/Q _6027_/Q _3394_/S VGND VGND VPWR VPWR _3380_/X sky130_fd_sc_hd__mux2_1
XANTENNA__2902__A2 _5094_/A1 VGND VGND VPWR VPWR sky130_fd_sc_hd__diode_2
X_5050_ _3626_/A _5974_/Q _5054_/S VGND VGND VPWR VPWR _5974_/D sky130_fd_sc_hd__mux2_1
XANTENNA_clkbuf_leaf_41_clk_A clkload1/A VGND VGND VPWR VPWR sky130_fd_sc_hd__diode_2
X_4001_ _5637_/Q _5638_/Q _4005_/S VGND VGND VPWR VPWR _5637_/D sky130_fd_sc_hd__mux2_1
XFILLER_27_3 VGND VGND VPWR VPWR sky130_fd_sc_hd__decap_6
XFILLER_1_51 VGND VGND VPWR VPWR sky130_fd_sc_hd__decap_4
XFILLER_80_413 VGND VGND VPWR VPWR sky130_fd_sc_hd__fill_1
X_5952_ _5952_/CLK _5952_/D fanout334/X VGND VGND VPWR VPWR _5952_/Q sky130_fd_sc_hd__dfrtp_1
XFILLER_25_329 VGND VGND VPWR VPWR sky130_fd_sc_hd__decap_6
XFILLER_37_167 VGND VGND VPWR VPWR sky130_fd_sc_hd__fill_1
X_4903_ _5910_/Q _4975_/A2 _4902_/X VGND VGND VPWR VPWR _5910_/D sky130_fd_sc_hd__a21o_1
XFILLER_80_479 VGND VGND VPWR VPWR sky130_fd_sc_hd__fill_1
XFILLER_61_682 VGND VGND VPWR VPWR sky130_fd_sc_hd__fill_1
X_5883_ _6092_/CLK _5883_/D fanout347/X VGND VGND VPWR VPWR _5883_/Q sky130_fd_sc_hd__dfrtp_1
XTAP_TAPCELL_ROW_51_817 VGND VPWR sky130_fd_sc_hd__tapvpwrvgnd_1
X_4834_ _5518_/Q hold249/X _4863_/S VGND VGND VPWR VPWR _5868_/D sky130_fd_sc_hd__mux2_1
X_4765_ hold130/X _3762_/X _4776_/S VGND VGND VPWR VPWR _5803_/D sky130_fd_sc_hd__mux2_1
XANTENNA_fanout121_A _5038_/B1 VGND VGND VPWR VPWR sky130_fd_sc_hd__diode_2
XANTENNA__4591__A1 _5763_/Q VGND VGND VPWR VPWR sky130_fd_sc_hd__diode_2
X_3716_ _3716_/A _3716_/B _3716_/C _3716_/D VGND VGND VPWR VPWR _3717_/C sky130_fd_sc_hd__or4_1
XTAP_TAPCELL_ROW_31_563 VGND VPWR sky130_fd_sc_hd__tapvpwrvgnd_1
X_4696_ _4692_/X _4694_/X _4695_/X _4226_/S _4720_/C1 VGND VGND VPWR VPWR _4696_/X
+ sky130_fd_sc_hd__a221o_1
XANTENNA__5936__RESET_B fanout307/X VGND VGND VPWR VPWR sky130_fd_sc_hd__diode_2
X_3647_ _3647_/A _6043_/Q VGND VGND VPWR VPWR _3648_/B sky130_fd_sc_hd__xnor2_1
XFILLER_20_27 VGND VGND VPWR VPWR sky130_fd_sc_hd__fill_1
XANTENNA__3146__A2 _2977_/Y VGND VGND VPWR VPWR sky130_fd_sc_hd__diode_2
X_3578_ _6101_/Q _4447_/B VGND VGND VPWR VPWR _3711_/A sky130_fd_sc_hd__and2b_1
X_5317_ _5327_/C _5315_/X _5318_/B _5310_/Y VGND VGND VPWR VPWR _6155_/D sky130_fd_sc_hd__a31o_1
XFILLER_0_417 VGND VGND VPWR VPWR sky130_fd_sc_hd__decap_3
Xhold14 hold14/A VGND VGND VPWR VPWR hold14/X sky130_fd_sc_hd__dlygate4sd3_1
XTAP_TAPCELL_ROW_59_917 VGND VPWR sky130_fd_sc_hd__tapvpwrvgnd_1
Xhold36 hold36/A VGND VGND VPWR VPWR hold36/X sky130_fd_sc_hd__dlygate4sd3_1
Xhold47 hold47/A VGND VGND VPWR VPWR hold47/X sky130_fd_sc_hd__dlygate4sd3_1
X_5248_ _5237_/X _5247_/Y _5245_/Y VGND VGND VPWR VPWR _5248_/Y sky130_fd_sc_hd__o21ai_1
XFILLER_29_69 VGND VGND VPWR VPWR sky130_fd_sc_hd__decap_4
Xhold25 hold25/A VGND VGND VPWR VPWR hold25/X sky130_fd_sc_hd__dlygate4sd3_1
X_5179_ hold332/X _4447_/B _5185_/S VGND VGND VPWR VPWR _6101_/D sky130_fd_sc_hd__mux2_1
XTAP_TAPCELL_ROW_3_222 VGND VPWR sky130_fd_sc_hd__tapvpwrvgnd_1
Xhold58 hold58/A VGND VGND VPWR VPWR hold58/X sky130_fd_sc_hd__dlygate4sd3_1
Xhold69 hold69/A VGND VGND VPWR VPWR hold69/X sky130_fd_sc_hd__dlygate4sd3_1
XTAP_TAPCELL_ROW_39_663 VGND VPWR sky130_fd_sc_hd__tapvpwrvgnd_1
XANTENNA__5111__S _5127_/B VGND VGND VPWR VPWR sky130_fd_sc_hd__diode_2
XFILLER_8_506 VGND VGND VPWR VPWR sky130_fd_sc_hd__decap_4
XANTENNA__4582__A1 _4686_/A1 VGND VGND VPWR VPWR sky130_fd_sc_hd__diode_2
XPHY_EDGE_ROW_7_Left_88 VGND VGND VPWR VPWR sky130_fd_sc_hd__decap_3
XANTENNA__3385__A2 _3396_/A VGND VGND VPWR VPWR sky130_fd_sc_hd__diode_2
XFILLER_6_29 VGND VGND VPWR VPWR sky130_fd_sc_hd__fill_1
XFILLER_4_701 VPWR VGND VPWR VGND sky130_ef_sc_hd__decap_12
XANTENNA__2977__Y _2977_/Y VGND VGND VPWR VPWR sky130_fd_sc_hd__diode_2
XFILLER_3_233 VGND VGND VPWR VPWR sky130_fd_sc_hd__decap_3
XFILLER_74_251 VGND VGND VPWR VPWR sky130_fd_sc_hd__fill_1
XANTENNA__3330__A _5369_/A VGND VGND VPWR VPWR sky130_fd_sc_hd__diode_2
XFILLER_50_608 VGND VGND VPWR VPWR sky130_fd_sc_hd__fill_1
XANTENNA__4860__S _4864_/S VGND VGND VPWR VPWR sky130_fd_sc_hd__diode_2
X_2880_ _6077_/Q _2786_/X _2926_/B1 _6069_/Q VGND VGND VPWR VPWR _2880_/X sky130_fd_sc_hd__a22o_1
XANTENNA__4573__A1 _5761_/Q VGND VGND VPWR VPWR sky130_fd_sc_hd__diode_2
X_4550_ _5759_/Q _2837_/B _4829_/B _5739_/Q VGND VGND VPWR VPWR _5759_/D sky130_fd_sc_hd__a22o_1
X_4481_ _4482_/B _4482_/C _4482_/A VGND VGND VPWR VPWR _4481_/Y sky130_fd_sc_hd__o21ai_1
X_3501_ _3508_/A _3534_/B VGND VGND VPWR VPWR _3501_/X sky130_fd_sc_hd__or2_1
X_3432_ hold25/X _5587_/Q _3434_/S VGND VGND VPWR VPWR _5546_/D sky130_fd_sc_hd__mux2_1
X_6151_ _6160_/CLK _6151_/D fanout310/X VGND VGND VPWR VPWR _6151_/Q sky130_fd_sc_hd__dfrtp_1
X_3363_ _3749_/A _3363_/B _6046_/Q VGND VGND VPWR VPWR _3366_/B sky130_fd_sc_hd__or3b_1
X_5102_ _6025_/Q _6167_/Q _5127_/B VGND VGND VPWR VPWR _6025_/D sky130_fd_sc_hd__mux2_1
X_6082_ _6094_/CLK _6082_/D fanout350/X VGND VGND VPWR VPWR _6082_/Q sky130_fd_sc_hd__dfrtp_1
XFILLER_57_207 VGND VGND VPWR VPWR sky130_fd_sc_hd__fill_1
X_3294_ _6174_/Q _2758_/Y _3355_/D _3289_/X _3293_/X VGND VGND VPWR VPWR _3295_/D
+ sky130_fd_sc_hd__a2111o_1
XFILLER_38_421 VGND VGND VPWR VPWR sky130_fd_sc_hd__fill_1
X_5033_ hold457/X _5043_/A2 _5032_/X VGND VGND VPWR VPWR _5962_/D sky130_fd_sc_hd__a21o_1
XFILLER_53_457 VGND VGND VPWR VPWR sky130_fd_sc_hd__fill_1
XANTENNA__3240__A _3240_/A VGND VGND VPWR VPWR sky130_fd_sc_hd__diode_2
XFILLER_26_649 VGND VGND VPWR VPWR sky130_fd_sc_hd__fill_1
XTAP_TAPCELL_ROW_36_633 VGND VPWR sky130_fd_sc_hd__tapvpwrvgnd_1
XTAP_TAPCELL_ROW_64_986 VGND VPWR sky130_fd_sc_hd__tapvpwrvgnd_1
XTAP_TAPCELL_ROW_64_975 VGND VPWR sky130_fd_sc_hd__tapvpwrvgnd_1
X_5935_ _6097_/CLK _5935_/D fanout301/X VGND VGND VPWR VPWR _5935_/Q sky130_fd_sc_hd__dfrtp_1
XANTENNA_fanout336_A fanout341/X VGND VGND VPWR VPWR sky130_fd_sc_hd__diode_2
X_5866_ _6050_/CLK _5866_/D fanout290/X VGND VGND VPWR VPWR _5866_/Q sky130_fd_sc_hd__dfrtp_1
X_4817_ _4447_/B _4823_/A2 _4824_/B1 hold116/X VGND VGND VPWR VPWR _5853_/D sky130_fd_sc_hd__a22o_1
X_5797_ _6111_/CLK _5797_/D fanout327/X VGND VGND VPWR VPWR _5797_/Q sky130_fd_sc_hd__dfrtp_2
X_4748_ _5967_/Q _4748_/A2 _4243_/S _4747_/X VGND VGND VPWR VPWR _4748_/X sky130_fd_sc_hd__a211o_1
XANTENNA_fanout124_X _5026_/B1 VGND VGND VPWR VPWR sky130_fd_sc_hd__diode_2
X_4679_ _5925_/Q _5766_/Q _4679_/S VGND VGND VPWR VPWR _4679_/X sky130_fd_sc_hd__mux2_1
XPHY_EDGE_ROW_1_Right_1 VGND VGND VPWR VPWR sky130_fd_sc_hd__decap_3
XFILLER_0_225 VPWR VGND VPWR VGND sky130_ef_sc_hd__decap_12
XANTENNA__5106__S _5109_/S VGND VGND VPWR VPWR sky130_fd_sc_hd__diode_2
XFILLER_48_207 VGND VGND VPWR VPWR sky130_fd_sc_hd__fill_2
XFILLER_56_56 VGND VGND VPWR VPWR sky130_fd_sc_hd__fill_1
XANTENNA__3150__A _5520_/Q VGND VGND VPWR VPWR sky130_fd_sc_hd__diode_2
XANTENNA_fanout37_X _3725_/C VGND VGND VPWR VPWR sky130_fd_sc_hd__diode_2
XFILLER_16_159 VGND VGND VPWR VPWR sky130_fd_sc_hd__decap_8
XTAP_TAPCELL_ROW_14_349 VGND VPWR sky130_fd_sc_hd__tapvpwrvgnd_1
Xclkbuf_leaf_51_clk clkload0/A VGND VGND VPWR VPWR _6159_/CLK sky130_fd_sc_hd__clkbuf_8
XFILLER_12_365 VGND VGND VPWR VPWR sky130_fd_sc_hd__fill_2
XANTENNA__4555__A1 _5763_/Q VGND VGND VPWR VPWR sky130_fd_sc_hd__diode_2
XANTENNA__4855__S _4855_/S VGND VGND VPWR VPWR sky130_fd_sc_hd__diode_2
XANTENNA__3294__A1 _6174_/Q VGND VGND VPWR VPWR sky130_fd_sc_hd__diode_2
XFILLER_35_457 VPWR VGND VPWR VGND sky130_ef_sc_hd__decap_12
X_3981_ _3057_/B _3978_/C _3980_/Y VGND VGND VPWR VPWR _5620_/D sky130_fd_sc_hd__o21a_1
X_5720_ _3182_/A1 _5720_/D fanout295/X VGND VGND VPWR VPWR _5720_/Q sky130_fd_sc_hd__dfrtp_1
XTAP_TAPCELL_ROW_61_945 VGND VPWR sky130_fd_sc_hd__tapvpwrvgnd_1
X_2932_ _2783_/X _2931_/X _5192_/A2 _2722_/Y VGND VGND VPWR VPWR _2932_/X sky130_fd_sc_hd__a211o_1
XFILLER_22_118 VGND VGND VPWR VPWR sky130_fd_sc_hd__decap_8
Xclkbuf_leaf_42_clk clkload1/A VGND VGND VPWR VPWR _5690_/CLK sky130_fd_sc_hd__clkbuf_8
X_2863_ _5868_/Q _2783_/X _2862_/X _6115_/Q _2803_/A VGND VGND VPWR VPWR _2863_/X
+ sky130_fd_sc_hd__a2111o_1
X_5651_ _5685_/CLK _5651_/D fanout316/X VGND VGND VPWR VPWR _5651_/Q sky130_fd_sc_hd__dfrtp_1
XFILLER_31_685 VGND VGND VPWR VPWR sky130_fd_sc_hd__fill_1
X_2794_ _5999_/Q _2916_/B _2918_/B1 _6011_/Q VGND VGND VPWR VPWR _2794_/X sky130_fd_sc_hd__a22o_1
X_4602_ _5492_/Q _5798_/Q _4610_/S VGND VGND VPWR VPWR _4602_/X sky130_fd_sc_hd__mux2_1
X_5582_ _6120_/CLK _5582_/D fanout313/X VGND VGND VPWR VPWR _5582_/Q sky130_fd_sc_hd__dfrtp_1
XTAP_TAPCELL_ROW_41_691 VGND VPWR sky130_fd_sc_hd__tapvpwrvgnd_1
XANTENNA__4546__B2 _6109_/Q VGND VGND VPWR VPWR sky130_fd_sc_hd__diode_2
XFILLER_7_61 VGND VGND VPWR VPWR sky130_fd_sc_hd__fill_1
X_4533_ _4536_/A _4533_/B VGND VGND VPWR VPWR _4533_/Y sky130_fd_sc_hd__nand2_1
Xhold303 _5895_/Q VGND VGND VPWR VPWR hold303/X sky130_fd_sc_hd__dlygate4sd3_1
Xhold314 _5824_/Q VGND VGND VPWR VPWR hold314/X sky130_fd_sc_hd__dlygate4sd3_1
Xhold325 _5876_/Q VGND VGND VPWR VPWR hold325/X sky130_fd_sc_hd__dlygate4sd3_1
XFILLER_7_391 VGND VGND VPWR VPWR sky130_fd_sc_hd__fill_1
Xhold336 _6099_/Q VGND VGND VPWR VPWR hold336/X sky130_fd_sc_hd__dlygate4sd3_1
Xhold358 _6043_/Q VGND VGND VPWR VPWR hold358/X sky130_fd_sc_hd__dlygate4sd3_1
Xhold347 _6152_/Q VGND VGND VPWR VPWR hold347/X sky130_fd_sc_hd__dlygate4sd3_1
Xhold369 _6040_/Q VGND VGND VPWR VPWR hold369/X sky130_fd_sc_hd__dlygate4sd3_1
X_4464_ _4464_/A _4530_/B VGND VGND VPWR VPWR _4479_/C sky130_fd_sc_hd__xnor2_1
X_3415_ hold68/X _5641_/Q _3416_/S VGND VGND VPWR VPWR _5531_/D sky130_fd_sc_hd__mux2_1
X_4395_ _4408_/A _4408_/C VGND VGND VPWR VPWR _4395_/Y sky130_fd_sc_hd__xnor2_1
X_6134_ _6176_/CLK _6134_/D fanout312/X VGND VGND VPWR VPWR _6134_/Q sky130_fd_sc_hd__dfrtp_1
X_3346_ _3362_/A _3360_/B _3360_/C _3360_/D VGND VGND VPWR VPWR _3351_/B sky130_fd_sc_hd__or4_1
X_6065_ _6115_/CLK _6065_/D fanout341/X VGND VGND VPWR VPWR _6065_/Q sky130_fd_sc_hd__dfrtp_1
X_5016_ _4645_/X _5024_/A2 _5024_/B1 _4934_/X VGND VGND VPWR VPWR _5016_/X sky130_fd_sc_hd__a22o_1
X_3277_ _6026_/Q _5397_/A VGND VGND VPWR VPWR _3355_/B sky130_fd_sc_hd__and2b_1
XANTENNA_fanout286_A fanout287/X VGND VGND VPWR VPWR sky130_fd_sc_hd__diode_2
XFILLER_38_251 VGND VGND VPWR VPWR sky130_fd_sc_hd__fill_1
XFILLER_38_273 VGND VGND VPWR VPWR sky130_fd_sc_hd__fill_2
XTAP_TAPCELL_ROW_49_791 VGND VPWR sky130_fd_sc_hd__tapvpwrvgnd_1
XFILLER_26_424 VGND VGND VPWR VPWR sky130_fd_sc_hd__decap_8
XANTENNA__5026__A2 _5026_/A2 VGND VGND VPWR VPWR sky130_fd_sc_hd__diode_2
XFILLER_26_457 VGND VGND VPWR VPWR sky130_fd_sc_hd__decap_6
X_5918_ _6144_/CLK _5918_/D fanout330/X VGND VGND VPWR VPWR _5918_/Q sky130_fd_sc_hd__dfrtp_1
XFILLER_41_416 VGND VGND VPWR VPWR sky130_fd_sc_hd__decap_3
Xclkbuf_leaf_33_clk clkload2/A VGND VGND VPWR VPWR _6131_/CLK sky130_fd_sc_hd__clkbuf_8
XTAP_TAPCELL_ROW_11_319 VGND VPWR sky130_fd_sc_hd__tapvpwrvgnd_1
XFILLER_22_674 VGND VGND VPWR VPWR sky130_fd_sc_hd__fill_1
XFILLER_22_696 VGND VGND VPWR VPWR sky130_fd_sc_hd__decap_4
X_5849_ _6026_/CLK _5849_/D fanout277/X VGND VGND VPWR VPWR _5849_/Q sky130_fd_sc_hd__dfrtp_1
XFILLER_42_58 VGND VGND VPWR VPWR sky130_fd_sc_hd__fill_1
XANTENNA__4005__S _4005_/S VGND VGND VPWR VPWR sky130_fd_sc_hd__diode_2
XFILLER_76_313 VGND VGND VPWR VPWR sky130_fd_sc_hd__fill_1
XANTENNA__6057__RESET_B fanout283/X VGND VGND VPWR VPWR sky130_fd_sc_hd__diode_2
XFILLER_67_99 VGND VGND VPWR VPWR sky130_fd_sc_hd__decap_4
XFILLER_64_519 VGND VGND VPWR VPWR sky130_fd_sc_hd__decap_3
XTAP_TAPCELL_ROW_19_419 VGND VPWR sky130_fd_sc_hd__tapvpwrvgnd_1
XFILLER_29_262 VPWR VGND VPWR VGND sky130_ef_sc_hd__decap_12
XTAP_TAPCELL_ROW_67_1022 VGND VPWR sky130_fd_sc_hd__tapvpwrvgnd_1
XANTENNA__3028__A1 _5493_/Q VGND VGND VPWR VPWR sky130_fd_sc_hd__diode_2
XANTENNA__5017__A2 _5027_/A2 VGND VGND VPWR VPWR sky130_fd_sc_hd__diode_2
XANTENNA__3028__B2 _5473_/Q VGND VGND VPWR VPWR sky130_fd_sc_hd__diode_2
XFILLER_44_287 VGND VGND VPWR VPWR sky130_fd_sc_hd__decap_3
Xclkbuf_leaf_24_clk clkload2/A VGND VGND VPWR VPWR _6021_/CLK sky130_fd_sc_hd__clkbuf_8
XFILLER_9_623 VGND VGND VPWR VPWR sky130_fd_sc_hd__fill_1
XANTENNA__4528__A1 _4522_/C VGND VGND VPWR VPWR sky130_fd_sc_hd__diode_2
XANTENNA__3200__A1 _5471_/Q VGND VGND VPWR VPWR sky130_fd_sc_hd__diode_2
XTAP_TAPCELL_ROW_78_1151 VGND VPWR sky130_fd_sc_hd__tapvpwrvgnd_1
XFILLER_4_350 VPWR VGND VPWR VGND sky130_ef_sc_hd__decap_12
X_3200_ _4964_/A0 _5471_/Q _3203_/S VGND VGND VPWR VPWR _5471_/D sky130_fd_sc_hd__mux2_1
X_4180_ _4179_/X _4173_/X _4235_/S VGND VGND VPWR VPWR _4181_/B sky130_fd_sc_hd__mux2_1
X_3131_ _2968_/X _3128_/X _3129_/X _3130_/X _2981_/X VGND VGND VPWR VPWR _3131_/X
+ sky130_fd_sc_hd__o311a_1
X_3062_ _5600_/Q _5649_/Q VGND VGND VPWR VPWR _3075_/A sky130_fd_sc_hd__xor2_1
XFILLER_35_221 VGND VGND VPWR VPWR sky130_fd_sc_hd__decap_3
XANTENNA__5008__A2 _5024_/A2 VGND VGND VPWR VPWR sky130_fd_sc_hd__diode_2
XTAP_TAPCELL_ROW_46_761 VGND VPWR sky130_fd_sc_hd__tapvpwrvgnd_1
XTAP_TAPCELL_ROW_46_750 VGND VPWR sky130_fd_sc_hd__tapvpwrvgnd_1
Xclkbuf_leaf_15_clk clkbuf_leaf_9_clk/A VGND VGND VPWR VPWR _5942_/CLK sky130_fd_sc_hd__clkbuf_8
XFILLER_16_490 VGND VGND VPWR VPWR sky130_fd_sc_hd__fill_2
X_3964_ _4052_/S _3976_/A VGND VGND VPWR VPWR _3967_/B sky130_fd_sc_hd__nand2_1
X_2915_ _6078_/Q _2910_/B _2921_/B1 _6070_/Q VGND VGND VPWR VPWR _2915_/X sky130_fd_sc_hd__a22o_1
X_5703_ _5792_/CLK _5703_/D fanout296/X VGND VGND VPWR VPWR _5703_/Q sky130_fd_sc_hd__dfrtp_1
X_3895_ _5578_/Q _5579_/Q _3895_/C VGND VGND VPWR VPWR _3908_/B sky130_fd_sc_hd__and3_1
X_2846_ _5468_/Q _2935_/B _2937_/B VGND VGND VPWR VPWR _2846_/X sky130_fd_sc_hd__o21a_1
X_5634_ _5690_/CLK hold2/X VGND VGND VPWR VPWR hold9/A sky130_fd_sc_hd__dfxtp_1
XFILLER_31_493 VGND VGND VPWR VPWR sky130_fd_sc_hd__decap_8
XANTENNA__5192__A1 _2864_/A VGND VGND VPWR VPWR sky130_fd_sc_hd__diode_2
X_2777_ _4336_/S _3207_/S VGND VGND VPWR VPWR _2781_/S sky130_fd_sc_hd__or2_1
X_5565_ _5697_/CLK _5565_/D fanout319/X VGND VGND VPWR VPWR _5565_/Q sky130_fd_sc_hd__dfrtp_1
Xhold100 _5849_/Q VGND VGND VPWR VPWR hold100/X sky130_fd_sc_hd__dlygate4sd3_1
XANTENNA__5192__B2 _5737_/Q VGND VGND VPWR VPWR sky130_fd_sc_hd__diode_2
Xhold144 _5731_/Q VGND VGND VPWR VPWR hold144/X sky130_fd_sc_hd__dlygate4sd3_1
XANTENNA_fanout201_A _6113_/Q VGND VGND VPWR VPWR sky130_fd_sc_hd__diode_2
X_5496_ _5635_/CLK _5496_/D VGND VGND VPWR VPWR hold57/A sky130_fd_sc_hd__dfxtp_1
XFILLER_2_309 VPWR VGND VPWR VGND sky130_ef_sc_hd__decap_12
X_4516_ _4504_/B _4507_/B _4504_/A VGND VGND VPWR VPWR _4520_/A sky130_fd_sc_hd__a21boi_1
Xhold133 _5859_/Q VGND VGND VPWR VPWR hold133/X sky130_fd_sc_hd__dlygate4sd3_1
Xhold122 _5811_/Q VGND VGND VPWR VPWR hold122/X sky130_fd_sc_hd__dlygate4sd3_1
Xhold111 _5802_/Q VGND VGND VPWR VPWR hold111/X sky130_fd_sc_hd__dlygate4sd3_1
Xhold177 _6081_/Q VGND VGND VPWR VPWR hold177/X sky130_fd_sc_hd__dlygate4sd3_1
Xhold166 _6008_/Q VGND VGND VPWR VPWR hold166/X sky130_fd_sc_hd__dlygate4sd3_1
X_4447_ _4447_/A _4447_/B _4447_/C VGND VGND VPWR VPWR _4460_/B sky130_fd_sc_hd__and3_1
Xhold155 _5505_/Q VGND VGND VPWR VPWR hold155/X sky130_fd_sc_hd__dlygate4sd3_1
Xhold199 _6077_/Q VGND VGND VPWR VPWR hold199/X sky130_fd_sc_hd__dlygate4sd3_1
Xhold188 _5617_/Q VGND VGND VPWR VPWR hold188/X sky130_fd_sc_hd__dlygate4sd3_1
XANTENNA_input6_A uio_in[7] VGND VGND VPWR VPWR sky130_fd_sc_hd__diode_2
X_4378_ _4378_/A _4378_/B VGND VGND VPWR VPWR _4378_/Y sky130_fd_sc_hd__xnor2_1
X_6117_ _6120_/CLK _6117_/D fanout313/X VGND VGND VPWR VPWR _6117_/Q sky130_fd_sc_hd__dfrtp_1
XANTENNA__6150__RESET_B fanout310/X VGND VGND VPWR VPWR sky130_fd_sc_hd__diode_2
XANTENNA_fanout191_X _5406_/A VGND VGND VPWR VPWR sky130_fd_sc_hd__diode_2
X_3329_ _4551_/B _3747_/C VGND VGND VPWR VPWR _3329_/X sky130_fd_sc_hd__and2_1
XFILLER_27_711 VGND VGND VPWR VPWR sky130_fd_sc_hd__fill_2
X_6048_ _6110_/CLK _6048_/D fanout301/X VGND VGND VPWR VPWR _6048_/Q sky130_fd_sc_hd__dfrtp_1
XFILLER_26_221 VPWR VGND VPWR VGND sky130_ef_sc_hd__decap_12
XFILLER_26_265 VPWR VGND VPWR VGND sky130_ef_sc_hd__decap_12
XFILLER_26_298 VGND VGND VPWR VPWR sky130_fd_sc_hd__decap_8
XFILLER_53_57 VPWR VGND VPWR VGND sky130_ef_sc_hd__decap_12
XANTENNA__4758__A1 _5797_/Q VGND VGND VPWR VPWR sky130_fd_sc_hd__diode_2
XANTENNA__4758__B2 _3544_/X VGND VGND VPWR VPWR sky130_fd_sc_hd__diode_2
XTAP_TAPCELL_ROW_24_477 VGND VPWR sky130_fd_sc_hd__tapvpwrvgnd_1
XANTENNA__5183__A1 _3639_/A VGND VGND VPWR VPWR sky130_fd_sc_hd__diode_2
XFILLER_5_169 VPWR VGND VPWR VGND sky130_ef_sc_hd__decap_12
XFILLER_1_353 VGND VGND VPWR VPWR sky130_fd_sc_hd__decap_6
XANTENNA__4694__B1 _4750_/C1 VGND VGND VPWR VPWR sky130_fd_sc_hd__diode_2
XTAP_TAPCELL_ROW_73_1092 VGND VPWR sky130_fd_sc_hd__tapvpwrvgnd_1
XANTENNA__3162__X _6141_/D VGND VGND VPWR VPWR sky130_fd_sc_hd__diode_2
XFILLER_76_165 VGND VGND VPWR VPWR sky130_fd_sc_hd__fill_1
XFILLER_64_305 VGND VGND VPWR VPWR sky130_fd_sc_hd__fill_1
XFILLER_32_202 VPWR VGND VPWR VGND sky130_ef_sc_hd__decap_12
XTAP_TAPCELL_ROW_43_720 VGND VPWR sky130_fd_sc_hd__tapvpwrvgnd_1
X_3680_ _5801_/Q _3680_/B VGND VGND VPWR VPWR _3718_/D sky130_fd_sc_hd__nand2_1
XFILLER_57_3 VGND VGND VPWR VPWR sky130_fd_sc_hd__decap_4
X_5350_ _5362_/B _5362_/C VGND VGND VPWR VPWR _5350_/X sky130_fd_sc_hd__or2_1
X_4301_ _5572_/Q _5580_/Q _4307_/S VGND VGND VPWR VPWR _4301_/X sky130_fd_sc_hd__mux2_1
XFILLER_5_681 VPWR VGND VPWR VGND sky130_ef_sc_hd__decap_12
X_5281_ _5287_/A _5288_/A VGND VGND VPWR VPWR _5282_/B sky130_fd_sc_hd__nand2b_1
X_4232_ _5909_/Q _5766_/Q _4232_/S VGND VGND VPWR VPWR _4232_/X sky130_fd_sc_hd__mux2_1
Xclkbuf_leaf_4_clk clkload0/A VGND VGND VPWR VPWR clkload6/A sky130_fd_sc_hd__clkbuf_8
X_4163_ _4155_/B _4161_/X _4162_/X _4157_/A VGND VGND VPWR VPWR _5701_/D sky130_fd_sc_hd__o31a_1
X_4094_ _6177_/Q _5699_/Q _5700_/Q VGND VGND VPWR VPWR _4266_/A sky130_fd_sc_hd__or3_2
XFILLER_68_699 VGND VGND VPWR VPWR sky130_fd_sc_hd__fill_1
XFILLER_67_143 VGND VGND VPWR VPWR sky130_fd_sc_hd__decap_4
X_3114_ hold141/X _3113_/X _3114_/S VGND VGND VPWR VPWR _6117_/D sky130_fd_sc_hd__mux2_1
X_3045_ _5524_/Q _3150_/B _6096_/Q VGND VGND VPWR VPWR _3045_/X sky130_fd_sc_hd__or3_1
XFILLER_55_349 VGND VGND VPWR VPWR sky130_fd_sc_hd__fill_1
XANTENNA__2999__A0 _5517_/Q VGND VGND VPWR VPWR sky130_fd_sc_hd__diode_2
XANTENNA__4988__B2 _4892_/X VGND VGND VPWR VPWR sky130_fd_sc_hd__diode_2
X_4996_ _4565_/X _5024_/A2 _5024_/B1 _4904_/X VGND VGND VPWR VPWR _4996_/X sky130_fd_sc_hd__a22o_1
XFILLER_63_393 VGND VGND VPWR VPWR sky130_fd_sc_hd__fill_1
X_3947_ hold442/X _3541_/Y _5353_/A VGND VGND VPWR VPWR _5605_/D sky130_fd_sc_hd__mux2_1
XFILLER_23_279 VGND VGND VPWR VPWR sky130_fd_sc_hd__fill_1
XTAP_TAPCELL_ROW_21_447 VGND VPWR sky130_fd_sc_hd__tapvpwrvgnd_1
X_3878_ _3880_/B _3876_/X _3764_/X VGND VGND VPWR VPWR _3878_/X sky130_fd_sc_hd__o21a_1
XANTENNA__5165__A1 _5725_/Q VGND VGND VPWR VPWR sky130_fd_sc_hd__diode_2
X_2829_ _5471_/Q _2823_/Y _2824_/X _2828_/X VGND VGND VPWR VPWR _2829_/X sky130_fd_sc_hd__o211a_1
X_5617_ _6113_/CLK _5617_/D fanout337/X VGND VGND VPWR VPWR _5617_/Q sky130_fd_sc_hd__dfrtp_1
X_5548_ _6120_/CLK _5548_/D VGND VGND VPWR VPWR hold26/A sky130_fd_sc_hd__dfxtp_1
XANTENNA_fanout204_X _2871_/C VGND VGND VPWR VPWR sky130_fd_sc_hd__diode_2
XANTENNA__2923__B1 _2910_/B VGND VGND VPWR VPWR sky130_fd_sc_hd__diode_2
X_5479_ _5635_/CLK hold13/X VGND VGND VPWR VPWR hold12/A sky130_fd_sc_hd__dfxtp_1
XANTENNA__4676__B1 _4684_/B1 VGND VGND VPWR VPWR sky130_fd_sc_hd__diode_2
XFILLER_61_308 VGND VGND VPWR VPWR sky130_fd_sc_hd__fill_1
XTAP_TAPCELL_ROW_29_547 VGND VPWR sky130_fd_sc_hd__tapvpwrvgnd_1
XFILLER_64_67 VGND VGND VPWR VPWR sky130_fd_sc_hd__decap_3
XTAP_TAPCELL_ROW_57_889 VGND VPWR sky130_fd_sc_hd__tapvpwrvgnd_1
XTAP_TAPCELL_ROW_1_194 VGND VPWR sky130_fd_sc_hd__tapvpwrvgnd_1
XANTENNA__3403__A1 _5520_/Q VGND VGND VPWR VPWR sky130_fd_sc_hd__diode_2
XFILLER_42_577 VGND VGND VPWR VPWR sky130_fd_sc_hd__decap_4
Xfanout72 _4166_/C VGND VGND VPWR VPWR _4683_/A2 sky130_fd_sc_hd__buf_2
Xfanout83 _5447_/B VGND VGND VPWR VPWR _5441_/B sky130_fd_sc_hd__buf_2
Xfanout50 _4551_/X VGND VGND VPWR VPWR _5863_/D sky130_fd_sc_hd__buf_2
Xfanout61 _3747_/X VGND VGND VPWR VPWR _5055_/S sky130_fd_sc_hd__clkbuf_2
Xfanout94 _4452_/B VGND VGND VPWR VPWR _4530_/B sky130_fd_sc_hd__buf_2
XANTENNA__5156__A1 _5494_/Q VGND VGND VPWR VPWR sky130_fd_sc_hd__diode_2
XTAP_TAPCELL_ROW_75_1121 VGND VPWR sky130_fd_sc_hd__tapvpwrvgnd_1
XANTENNA__2914__B1 _2797_/X VGND VGND VPWR VPWR sky130_fd_sc_hd__diode_2
XFILLER_43_9 VGND VGND VPWR VPWR sky130_fd_sc_hd__fill_1
XANTENNA__6001__RESET_B fanout334/X VGND VGND VPWR VPWR sky130_fd_sc_hd__diode_2
XANTENNA__4667__B1 _4667_/B1 VGND VGND VPWR VPWR sky130_fd_sc_hd__diode_2
XTAP_TAPCELL_ROW_9_294 VGND VPWR sky130_fd_sc_hd__tapvpwrvgnd_1
XFILLER_49_121 VGND VGND VPWR VPWR sky130_fd_sc_hd__fill_1
XANTENNA__4863__S _4863_/S VGND VGND VPWR VPWR sky130_fd_sc_hd__diode_2
XFILLER_49_176 VGND VGND VPWR VPWR sky130_fd_sc_hd__decap_8
XFILLER_64_135 VGND VGND VPWR VPWR sky130_fd_sc_hd__decap_4
XFILLER_33_500 VGND VGND VPWR VPWR sky130_fd_sc_hd__decap_4
X_4850_ _5468_/Q hold271/X _4862_/S VGND VGND VPWR VPWR _5884_/D sky130_fd_sc_hd__mux2_1
XANTENNA_clkbuf_leaf_0_clk_A clkload0/A VGND VGND VPWR VPWR sky130_fd_sc_hd__diode_2
X_3801_ _3916_/S _3798_/X _3799_/Y _3800_/X _3826_/S VGND VGND VPWR VPWR _3801_/X
+ sky130_fd_sc_hd__o311a_1
X_4781_ _5519_/Q hold136/X _4805_/S VGND VGND VPWR VPWR _5818_/D sky130_fd_sc_hd__mux2_1
X_3732_ _6177_/Q _5699_/Q VGND VGND VPWR VPWR _4158_/B sky130_fd_sc_hd__nand2_1
XANTENNA__5147__A1 _5523_/Q VGND VGND VPWR VPWR sky130_fd_sc_hd__diode_2
Xclkload20 _5723_/CLK VGND VGND VPWR VPWR clkload20/Y sky130_fd_sc_hd__inv_8
XFILLER_9_272 VGND VGND VPWR VPWR sky130_fd_sc_hd__decap_8
X_3663_ _3663_/A _3663_/B VGND VGND VPWR VPWR _3663_/X sky130_fd_sc_hd__and2_1
Xclkload42 _6144_/CLK VGND VGND VPWR VPWR clkload42/Y sky130_fd_sc_hd__inv_8
X_5402_ _5402_/A _5402_/B _5402_/C VGND VGND VPWR VPWR _5409_/B sky130_fd_sc_hd__and3_1
Xclkload31 _5696_/CLK VGND VGND VPWR VPWR clkload31/Y sky130_fd_sc_hd__clkinv_4
Xclkload53 _6111_/CLK VGND VGND VPWR VPWR clkload53/Y sky130_fd_sc_hd__clkinv_4
X_5333_ _5329_/X _5332_/Y _5330_/Y VGND VGND VPWR VPWR _5333_/Y sky130_fd_sc_hd__o21ai_1
X_3594_ _4408_/A _5865_/Q _5738_/Q VGND VGND VPWR VPWR _3693_/A sky130_fd_sc_hd__nand3b_1
XANTENNA__3942__S _5353_/A VGND VGND VPWR VPWR sky130_fd_sc_hd__diode_2
XANTENNA__4658__A0 _5471_/Q VGND VGND VPWR VPWR sky130_fd_sc_hd__diode_2
X_5264_ _5264_/A _5264_/B VGND VGND VPWR VPWR _5264_/X sky130_fd_sc_hd__xor2_1
X_4215_ _5940_/Q _4177_/C _4176_/C _5907_/Q VGND VGND VPWR VPWR _4215_/X sky130_fd_sc_hd__a22o_1
X_5195_ _5207_/A _5195_/B VGND VGND VPWR VPWR _5196_/B sky130_fd_sc_hd__nand2_1
X_4146_ _4255_/C _4329_/B VGND VGND VPWR VPWR _4148_/D sky130_fd_sc_hd__or2_1
XFILLER_55_113 VGND VGND VPWR VPWR sky130_fd_sc_hd__decap_3
XFILLER_18_27 VGND VGND VPWR VPWR sky130_fd_sc_hd__fill_1
X_4077_ _5686_/Q _6197_/A _4076_/Y hold15/X VGND VGND VPWR VPWR _5668_/D sky130_fd_sc_hd__o22a_1
X_3028_ _5493_/Q _4618_/S _4682_/S _5473_/Q _4879_/B VGND VGND VPWR VPWR _3028_/X
+ sky130_fd_sc_hd__a221o_1
XTAP_TAPCELL_ROW_26_506 VGND VPWR sky130_fd_sc_hd__tapvpwrvgnd_1
XFILLER_70_149 VGND VGND VPWR VPWR sky130_fd_sc_hd__fill_2
XTAP_TAPCELL_ROW_54_859 VGND VPWR sky130_fd_sc_hd__tapvpwrvgnd_1
XFILLER_24_533 VGND VGND VPWR VPWR sky130_fd_sc_hd__fill_1
XFILLER_34_15 VGND VGND VPWR VPWR sky130_fd_sc_hd__fill_2
X_4979_ _4979_/A _4979_/B VGND VGND VPWR VPWR _4979_/Y sky130_fd_sc_hd__nor2_1
XFILLER_51_396 VGND VGND VPWR VPWR sky130_fd_sc_hd__fill_1
XANTENNA__2819__S0 _6114_/Q VGND VGND VPWR VPWR sky130_fd_sc_hd__diode_2
Xclkload3 clkload3/A VGND VGND VPWR VPWR clkload3/Y sky130_fd_sc_hd__inv_6
XANTENNA__5109__S _5109_/S VGND VGND VPWR VPWR sky130_fd_sc_hd__diode_2
XANTENNA__2911__A3 _2783_/B VGND VGND VPWR VPWR sky130_fd_sc_hd__diode_2
XTAP_TAPCELL_ROW_6_253 VGND VPWR sky130_fd_sc_hd__tapvpwrvgnd_1
Xfanout240 _5745_/Q VGND VGND VPWR VPWR _3623_/A sky130_fd_sc_hd__clkbuf_4
XTAP_TAPCELL_ROW_70_1051 VGND VPWR sky130_fd_sc_hd__tapvpwrvgnd_1
Xfanout273 fanout276/X VGND VGND VPWR VPWR fanout273/X sky130_fd_sc_hd__clkbuf_4
Xfanout251 _4813_/A1 VGND VGND VPWR VPWR _4873_/B sky130_fd_sc_hd__buf_2
Xfanout262 _5615_/Q VGND VGND VPWR VPWR _3967_/A sky130_fd_sc_hd__clkbuf_2
Xfanout295 fanout298/X VGND VGND VPWR VPWR fanout295/X sky130_fd_sc_hd__clkbuf_2
XFILLER_75_55 VGND VGND VPWR VPWR sky130_fd_sc_hd__fill_1
Xfanout284 fanout286/X VGND VGND VPWR VPWR fanout284/X sky130_fd_sc_hd__clkbuf_4
XFILLER_75_88 VGND VGND VPWR VPWR sky130_fd_sc_hd__fill_2
XFILLER_19_349 VPWR VGND VPWR VGND sky130_ef_sc_hd__decap_12
XFILLER_15_500 VGND VGND VPWR VPWR sky130_fd_sc_hd__decap_4
XANTENNA__3624__A1 _4428_/A VGND VGND VPWR VPWR sky130_fd_sc_hd__diode_2
XANTENNA_clkbuf_2_3__f_clk_X clkload2/A VGND VGND VPWR VPWR sky130_fd_sc_hd__diode_2
XFILLER_6_253 VGND VGND VPWR VPWR sky130_fd_sc_hd__decap_8
XFILLER_6_231 VGND VGND VPWR VPWR sky130_fd_sc_hd__fill_2
XANTENNA__2886__B _2886_/B VGND VGND VPWR VPWR sky130_fd_sc_hd__diode_2
XFILLER_69_238 VGND VGND VPWR VPWR sky130_fd_sc_hd__fill_1
X_4000_ _5636_/Q _5637_/Q _4005_/S VGND VGND VPWR VPWR _5636_/D sky130_fd_sc_hd__mux2_1
XFILLER_37_113 VGND VGND VPWR VPWR sky130_fd_sc_hd__fill_1
XFILLER_65_466 VGND VGND VPWR VPWR sky130_fd_sc_hd__fill_1
XFILLER_37_135 VGND VGND VPWR VPWR sky130_fd_sc_hd__decap_4
X_5951_ _6144_/CLK _5951_/D fanout330/X VGND VGND VPWR VPWR _5951_/Q sky130_fd_sc_hd__dfrtp_1
X_4902_ _4240_/X _4878_/A _4878_/B _4901_/X VGND VGND VPWR VPWR _4902_/X sky130_fd_sc_hd__a22o_1
XFILLER_52_149 VGND VGND VPWR VPWR sky130_fd_sc_hd__fill_1
X_5882_ _6091_/CLK _5882_/D fanout348/X VGND VGND VPWR VPWR _5882_/Q sky130_fd_sc_hd__dfrtp_1
XTAP_TAPCELL_ROW_51_818 VGND VPWR sky130_fd_sc_hd__tapvpwrvgnd_1
X_4833_ _5517_/Q hold285/X _4863_/S VGND VGND VPWR VPWR _5867_/D sky130_fd_sc_hd__mux2_1
XFILLER_60_193 VGND VGND VPWR VPWR sky130_fd_sc_hd__decap_3
XANTENNA__4576__C1 _4704_/C1 VGND VGND VPWR VPWR sky130_fd_sc_hd__diode_2
XANTENNA__3379__B1 _4544_/A VGND VGND VPWR VPWR sky130_fd_sc_hd__diode_2
X_4764_ hold111/X _3750_/X _4774_/S VGND VGND VPWR VPWR _5802_/D sky130_fd_sc_hd__mux2_1
X_3715_ _4408_/A _3715_/B _3715_/C _4829_/C VGND VGND VPWR VPWR _3716_/D sky130_fd_sc_hd__or4b_1
XTAP_TAPCELL_ROW_31_564 VGND VPWR sky130_fd_sc_hd__tapvpwrvgnd_1
X_4695_ _5760_/Q _5927_/Q _4735_/S VGND VGND VPWR VPWR _4695_/X sky130_fd_sc_hd__mux2_1
X_3646_ _4467_/A _6039_/Q VGND VGND VPWR VPWR _3648_/A sky130_fd_sc_hd__xnor2_1
X_3577_ _6099_/Q _3651_/B VGND VGND VPWR VPWR _3707_/A sky130_fd_sc_hd__xor2_1
X_5316_ _5315_/B _5315_/C _5315_/A VGND VGND VPWR VPWR _5318_/B sky130_fd_sc_hd__o21ai_1
X_5247_ _5247_/A _5247_/B VGND VGND VPWR VPWR _5247_/Y sky130_fd_sc_hd__nor2_1
XFILLER_29_15 VGND VGND VPWR VPWR sky130_fd_sc_hd__decap_6
XTAP_TAPCELL_ROW_59_918 VGND VPWR sky130_fd_sc_hd__tapvpwrvgnd_1
Xhold26 hold26/A VGND VGND VPWR VPWR hold26/X sky130_fd_sc_hd__dlygate4sd3_1
Xhold37 hold37/A VGND VGND VPWR VPWR hold37/X sky130_fd_sc_hd__dlygate4sd3_1
Xhold15 hold15/A VGND VGND VPWR VPWR hold15/X sky130_fd_sc_hd__dlygate4sd3_1
X_5178_ hold354/X _4427_/A _5185_/S VGND VGND VPWR VPWR _6100_/D sky130_fd_sc_hd__mux2_1
XTAP_TAPCELL_ROW_3_223 VGND VPWR sky130_fd_sc_hd__tapvpwrvgnd_1
Xhold48 hold48/A VGND VGND VPWR VPWR hold48/X sky130_fd_sc_hd__dlygate4sd3_1
XTAP_TAPCELL_ROW_3_212 VGND VPWR sky130_fd_sc_hd__tapvpwrvgnd_1
Xhold59 hold59/A VGND VGND VPWR VPWR hold59/X sky130_fd_sc_hd__dlygate4sd3_1
XANTENNA__3854__A1 _5427_/A VGND VGND VPWR VPWR sky130_fd_sc_hd__diode_2
XANTENNA_fanout271_X _4964_/A0 VGND VGND VPWR VPWR sky130_fd_sc_hd__diode_2
X_4129_ _5580_/Q _3907_/X _4120_/Y _4127_/X _4128_/Y VGND VGND VPWR VPWR _4130_/D
+ sky130_fd_sc_hd__a2111o_1
XFILLER_44_606 VGND VGND VPWR VPWR sky130_fd_sc_hd__fill_1
XANTENNA__4803__A0 _2824_/C VGND VGND VPWR VPWR sky130_fd_sc_hd__diode_2
XTAP_TAPCELL_ROW_39_664 VGND VPWR sky130_fd_sc_hd__tapvpwrvgnd_1
XFILLER_24_385 VGND VGND VPWR VPWR sky130_fd_sc_hd__fill_1
XFILLER_61_57 VPWR VGND VPWR VGND sky130_ef_sc_hd__decap_12
XFILLER_20_580 VGND VGND VPWR VPWR sky130_fd_sc_hd__fill_1
XFILLER_3_223 VGND VGND VPWR VPWR sky130_fd_sc_hd__fill_1
XFILLER_79_503 VGND VGND VPWR VPWR sky130_fd_sc_hd__fill_1
XANTENNA__2896__A2 _2916_/B VGND VGND VPWR VPWR sky130_fd_sc_hd__diode_2
XFILLER_10_94 VGND VGND VPWR VPWR sky130_fd_sc_hd__decap_3
XFILLER_19_113 VGND VGND VPWR VPWR sky130_fd_sc_hd__decap_8
XANTENNA__5047__A0 _4447_/B VGND VGND VPWR VPWR sky130_fd_sc_hd__diode_2
XFILLER_19_146 VGND VGND VPWR VPWR sky130_fd_sc_hd__fill_1
XFILLER_15_396 VPWR VGND VPWR VGND sky130_ef_sc_hd__decap_12
X_3500_ _3508_/A _3534_/B VGND VGND VPWR VPWR _3500_/X sky130_fd_sc_hd__and2_1
X_4480_ _4467_/A _3623_/A _4530_/B VGND VGND VPWR VPWR _4482_/C sky130_fd_sc_hd__o21a_1
X_3431_ hold17/X _5586_/Q _3434_/S VGND VGND VPWR VPWR _5545_/D sky130_fd_sc_hd__mux2_1
X_6150_ _6160_/CLK _6150_/D fanout310/X VGND VGND VPWR VPWR _6150_/Q sky130_fd_sc_hd__dfrtp_1
X_3362_ _3362_/A _3362_/B _3362_/C _3362_/D VGND VGND VPWR VPWR _3366_/A sky130_fd_sc_hd__or4_1
XANTENNA__2887__A2 _2916_/B VGND VGND VPWR VPWR sky130_fd_sc_hd__diode_2
X_5101_ hold402/X _5200_/C _5127_/B VGND VGND VPWR VPWR _6024_/D sky130_fd_sc_hd__mux2_1
X_6081_ _6093_/CLK _6081_/D fanout344/X VGND VGND VPWR VPWR _6081_/Q sky130_fd_sc_hd__dfrtp_1
X_3293_ _5442_/A _6032_/Q _3333_/B _3291_/Y _3356_/C VGND VGND VPWR VPWR _3293_/X
+ sky130_fd_sc_hd__a2111o_1
XFILLER_78_591 VGND VGND VPWR VPWR sky130_fd_sc_hd__fill_1
X_5032_ _4709_/X _5038_/A2 _5038_/B1 _4958_/X VGND VGND VPWR VPWR _5032_/X sky130_fd_sc_hd__a22o_1
XFILLER_65_252 VGND VGND VPWR VPWR sky130_fd_sc_hd__fill_1
XANTENNA__5038__B1 _5038_/B1 VGND VGND VPWR VPWR sky130_fd_sc_hd__diode_2
XANTENNA__3240__B _3240_/B VGND VGND VPWR VPWR sky130_fd_sc_hd__diode_2
XTAP_TAPCELL_ROW_36_634 VGND VPWR sky130_fd_sc_hd__tapvpwrvgnd_1
XTAP_TAPCELL_ROW_64_976 VGND VPWR sky130_fd_sc_hd__tapvpwrvgnd_1
X_5934_ _5967_/CLK _5934_/D fanout306/X VGND VGND VPWR VPWR _5934_/Q sky130_fd_sc_hd__dfrtp_1
XFILLER_80_277 VGND VGND VPWR VPWR sky130_fd_sc_hd__fill_1
XANTENNA__2811__A2 _2916_/B VGND VGND VPWR VPWR sky130_fd_sc_hd__diode_2
X_5865_ _6159_/CLK _5865_/D fanout282/X VGND VGND VPWR VPWR _5865_/Q sky130_fd_sc_hd__dfrtp_1
XFILLER_61_491 VGND VGND VPWR VPWR sky130_fd_sc_hd__fill_2
XTAP_TAPCELL_ROW_16_380 VGND VPWR sky130_fd_sc_hd__tapvpwrvgnd_1
XANTENNA__4352__A _6109_/Q VGND VGND VPWR VPWR sky130_fd_sc_hd__diode_2
X_4816_ _4427_/A _4823_/A2 _4824_/B1 hold104/X VGND VGND VPWR VPWR _5852_/D sky130_fd_sc_hd__a22o_1
XANTENNA_fanout329_A fanout352/X VGND VGND VPWR VPWR sky130_fd_sc_hd__diode_2
XFILLER_21_366 VGND VGND VPWR VPWR sky130_fd_sc_hd__decap_6
X_5796_ _6163_/CLK _5796_/D fanout312/X VGND VGND VPWR VPWR _5796_/Q sky130_fd_sc_hd__dfrtp_2
X_4747_ _5934_/Q _4747_/A2 _4747_/B1 _4746_/X VGND VGND VPWR VPWR _4747_/X sky130_fd_sc_hd__a22o_1
X_4678_ _4678_/A1 _4677_/X _4676_/X _4678_/C1 VGND VGND VPWR VPWR _4678_/X sky130_fd_sc_hd__o211a_1
XANTENNA_fanout117_X _5097_/S VGND VGND VPWR VPWR sky130_fd_sc_hd__diode_2
X_3629_ _2744_/A _2750_/Y _3680_/B _3628_/X VGND VGND VPWR VPWR _3632_/A sky130_fd_sc_hd__o211a_1
XFILLER_0_237 VPWR VGND VPWR VGND sky130_ef_sc_hd__decap_12
XFILLER_16_105 VGND VGND VPWR VPWR sky130_fd_sc_hd__decap_8
XFILLER_71_211 VGND VGND VPWR VPWR sky130_fd_sc_hd__decap_6
XANTENNA__4961__S _4973_/S VGND VGND VPWR VPWR sky130_fd_sc_hd__diode_2
XFILLER_31_108 VGND VGND VPWR VPWR sky130_fd_sc_hd__decap_4
XFILLER_72_89 VGND VGND VPWR VPWR sky130_fd_sc_hd__fill_2
XFILLER_72_78 VGND VGND VPWR VPWR sky130_fd_sc_hd__decap_6
XANTENNA__4262__A _5458_/C VGND VGND VPWR VPWR sky130_fd_sc_hd__diode_2
XANTENNA_clkbuf_leaf_40_clk_A clkload1/A VGND VGND VPWR VPWR sky130_fd_sc_hd__diode_2
XFILLER_12_355 VGND VGND VPWR VPWR sky130_fd_sc_hd__decap_8
XANTENNA__4712__C1 _3877_/S VGND VGND VPWR VPWR sky130_fd_sc_hd__diode_2
XFILLER_4_587 VGND VGND VPWR VPWR sky130_fd_sc_hd__fill_1
XFILLER_63_712 VGND VGND VPWR VPWR sky130_fd_sc_hd__fill_1
XFILLER_35_447 VGND VGND VPWR VPWR sky130_fd_sc_hd__fill_1
Xmax_cap80 _3536_/Y VGND VGND VPWR VPWR _3564_/B sky130_fd_sc_hd__clkbuf_2
XFILLER_35_469 VGND VGND VPWR VPWR sky130_fd_sc_hd__decap_8
X_3980_ _4541_/S _3979_/X _3978_/A VGND VGND VPWR VPWR _3980_/Y sky130_fd_sc_hd__a21oi_1
XTAP_TAPCELL_ROW_61_946 VGND VPWR sky130_fd_sc_hd__tapvpwrvgnd_1
X_2931_ _6066_/Q _5870_/Q _5994_/Q _5819_/Q _6114_/Q _6115_/Q VGND VGND VPWR VPWR
+ _2931_/X sky130_fd_sc_hd__mux4_1
X_5650_ _5685_/CLK _5650_/D fanout316/X VGND VGND VPWR VPWR _5650_/Q sky130_fd_sc_hd__dfrtp_1
Xclkbuf_0_clk clk VGND VGND VPWR VPWR clkbuf_0_clk/X sky130_fd_sc_hd__clkbuf_16
X_4601_ hold193/X _4753_/A2 _4600_/X VGND VGND VPWR VPWR _5773_/D sky130_fd_sc_hd__o21a_1
X_2862_ _2858_/X _2860_/X _2861_/X _2784_/X VGND VGND VPWR VPWR _2862_/X sky130_fd_sc_hd__o31a_1
XFILLER_30_141 VGND VGND VPWR VPWR sky130_fd_sc_hd__decap_6
X_2793_ _6003_/Q _2910_/B _2917_/A2 _6015_/Q VGND VGND VPWR VPWR _2793_/X sky130_fd_sc_hd__a22o_1
X_5581_ _5707_/CLK _5581_/D fanout289/X VGND VGND VPWR VPWR _5581_/Q sky130_fd_sc_hd__dfrtp_1
XTAP_TAPCELL_ROW_41_692 VGND VPWR sky130_fd_sc_hd__tapvpwrvgnd_1
X_4532_ _4536_/A _4533_/B VGND VGND VPWR VPWR _4532_/X sky130_fd_sc_hd__or2_1
Xhold304 _5835_/Q VGND VGND VPWR VPWR hold304/X sky130_fd_sc_hd__dlygate4sd3_1
Xhold315 _5833_/Q VGND VGND VPWR VPWR hold315/X sky130_fd_sc_hd__dlygate4sd3_1
Xhold326 _5883_/Q VGND VGND VPWR VPWR hold326/X sky130_fd_sc_hd__dlygate4sd3_1
X_4463_ _2744_/A _4357_/B _4462_/X VGND VGND VPWR VPWR _5744_/D sky130_fd_sc_hd__a21o_1
X_3414_ hold75/X _5640_/Q _3416_/S VGND VGND VPWR VPWR _5530_/D sky130_fd_sc_hd__mux2_1
Xhold337 _6042_/Q VGND VGND VPWR VPWR hold337/X sky130_fd_sc_hd__dlygate4sd3_1
Xhold348 _6134_/Q VGND VGND VPWR VPWR hold348/X sky130_fd_sc_hd__dlygate4sd3_1
Xhold359 _6119_/Q VGND VGND VPWR VPWR hold359/X sky130_fd_sc_hd__dlygate4sd3_1
XPHY_EDGE_ROW_15_Right_15 VGND VGND VPWR VPWR sky130_fd_sc_hd__decap_3
X_4394_ _4408_/A _4394_/B VGND VGND VPWR VPWR _4394_/Y sky130_fd_sc_hd__nand2_1
X_6133_ _6176_/CLK _6133_/D fanout312/X VGND VGND VPWR VPWR _6133_/Q sky130_fd_sc_hd__dfrtp_1
X_3345_ _3345_/A _3345_/B VGND VGND VPWR VPWR _3360_/D sky130_fd_sc_hd__or2_1
X_6064_ _6115_/CLK _6064_/D fanout341/X VGND VGND VPWR VPWR _6064_/Q sky130_fd_sc_hd__dfrtp_1
X_3276_ _6024_/Q _5200_/C VGND VGND VPWR VPWR _3355_/A sky130_fd_sc_hd__and2b_1
X_5015_ hold360/X _5027_/A2 _5014_/X VGND VGND VPWR VPWR _5953_/D sky130_fd_sc_hd__a21o_1
XANTENNA_fanout279_A fanout287/X VGND VGND VPWR VPWR sky130_fd_sc_hd__diode_2
XTAP_TAPCELL_ROW_49_792 VGND VPWR sky130_fd_sc_hd__tapvpwrvgnd_1
XANTENNA__4781__S _4805_/S VGND VGND VPWR VPWR sky130_fd_sc_hd__diode_2
XFILLER_53_244 VGND VGND VPWR VPWR sky130_fd_sc_hd__fill_1
XPHY_EDGE_ROW_24_Right_24 VGND VGND VPWR VPWR sky130_fd_sc_hd__decap_3
X_5917_ _5952_/CLK _5917_/D fanout330/X VGND VGND VPWR VPWR _5917_/Q sky130_fd_sc_hd__dfrtp_1
XFILLER_42_15 VPWR VGND VPWR VGND sky130_ef_sc_hd__decap_12
X_5848_ _6026_/CLK _5848_/D fanout280/X VGND VGND VPWR VPWR _5848_/Q sky130_fd_sc_hd__dfrtp_1
X_5779_ _6032_/CLK _5779_/D fanout291/X VGND VGND VPWR VPWR _5779_/Q sky130_fd_sc_hd__dfrtp_1
XANTENNA__3745__B1 _4870_/A1 VGND VGND VPWR VPWR sky130_fd_sc_hd__diode_2
XPHY_EDGE_ROW_33_Right_33 VGND VGND VPWR VPWR sky130_fd_sc_hd__decap_3
XPHY_EDGE_ROW_10_Left_91 VGND VGND VPWR VPWR sky130_fd_sc_hd__decap_3
XFILLER_76_369 VGND VGND VPWR VPWR sky130_fd_sc_hd__fill_1
XFILLER_45_712 VGND VGND VPWR VPWR sky130_fd_sc_hd__fill_1
XTAP_TAPCELL_ROW_67_1023 VGND VPWR sky130_fd_sc_hd__tapvpwrvgnd_1
XTAP_TAPCELL_ROW_67_1012 VGND VPWR sky130_fd_sc_hd__tapvpwrvgnd_1
XPHY_EDGE_ROW_42_Right_42 VGND VGND VPWR VPWR sky130_fd_sc_hd__decap_3
XFILLER_13_653 VPWR VGND VPWR VGND sky130_ef_sc_hd__decap_12
XFILLER_12_185 VGND VGND VPWR VPWR sky130_fd_sc_hd__fill_2
XANTENNA__3736__B1 _4331_/A1 VGND VGND VPWR VPWR sky130_fd_sc_hd__diode_2
XPHY_EDGE_ROW_51_Right_51 VGND VGND VPWR VPWR sky130_fd_sc_hd__decap_3
XFILLER_32_92 VGND VGND VPWR VPWR sky130_fd_sc_hd__fill_1
XTAP_TAPCELL_ROW_78_1152 VGND VPWR sky130_fd_sc_hd__tapvpwrvgnd_1
XFILLER_4_373 VGND VGND VPWR VPWR sky130_fd_sc_hd__fill_1
XFILLER_4_362 VGND VGND VPWR VPWR sky130_fd_sc_hd__fill_2
XANTENNA__4700__A2 _4166_/C VGND VGND VPWR VPWR sky130_fd_sc_hd__diode_2
X_3130_ _3130_/A _5946_/Q _4876_/A _3128_/B VGND VGND VPWR VPWR _3130_/X sky130_fd_sc_hd__or4bb_1
XPHY_EDGE_ROW_60_Right_60 VGND VGND VPWR VPWR sky130_fd_sc_hd__decap_3
X_3061_ _5604_/Q _5653_/Q VGND VGND VPWR VPWR _3061_/X sky130_fd_sc_hd__or2_1
XFILLER_36_712 VGND VGND VPWR VPWR sky130_fd_sc_hd__fill_1
XFILLER_75_391 VGND VGND VPWR VPWR sky130_fd_sc_hd__fill_1
XFILLER_35_211 VGND VGND VPWR VPWR sky130_fd_sc_hd__decap_6
XTAP_TAPCELL_ROW_46_751 VGND VPWR sky130_fd_sc_hd__tapvpwrvgnd_1
X_3963_ _5648_/Q _5686_/Q VGND VGND VPWR VPWR _4542_/A sky130_fd_sc_hd__nand2_4
X_2914_ _2910_/X _2911_/X _2912_/X _2913_/X _2797_/X VGND VGND VPWR VPWR _2930_/A
+ sky130_fd_sc_hd__o41a_1
X_5702_ _5942_/CLK _5702_/D fanout296/X VGND VGND VPWR VPWR _5702_/Q sky130_fd_sc_hd__dfrtp_1
X_3894_ _3783_/A _3888_/X _3893_/X VGND VGND VPWR VPWR _4106_/C sky130_fd_sc_hd__a21oi_1
X_2845_ _2823_/Y _2842_/Y _2843_/X _2844_/X _2825_/Y VGND VGND VPWR VPWR _2845_/X
+ sky130_fd_sc_hd__a311o_1
X_5633_ _5690_/CLK hold9/X VGND VGND VPWR VPWR _5633_/Q sky130_fd_sc_hd__dfxtp_1
XANTENNA__3727__B1 _5719_/Q VGND VGND VPWR VPWR sky130_fd_sc_hd__diode_2
XANTENNA__3945__S _5353_/A VGND VGND VPWR VPWR sky130_fd_sc_hd__diode_2
X_5564_ _6120_/CLK _5564_/D VGND VGND VPWR VPWR hold54/A sky130_fd_sc_hd__dfxtp_1
X_2776_ _2776_/A _5699_/Q _4320_/A _4138_/A VGND VGND VPWR VPWR _3204_/S sky130_fd_sc_hd__nor4_2
Xhold101 _5860_/Q VGND VGND VPWR VPWR hold101/X sky130_fd_sc_hd__dlygate4sd3_1
X_4515_ _4522_/B _4475_/B _4514_/Y VGND VGND VPWR VPWR _5748_/D sky130_fd_sc_hd__a21o_1
Xhold134 _6020_/Q VGND VGND VPWR VPWR hold134/X sky130_fd_sc_hd__dlygate4sd3_1
X_5495_ _5635_/CLK hold74/X VGND VGND VPWR VPWR hold73/A sky130_fd_sc_hd__dfxtp_1
Xhold112 _6122_/Q VGND VGND VPWR VPWR hold112/X sky130_fd_sc_hd__dlygate4sd3_1
Xhold123 _5855_/Q VGND VGND VPWR VPWR hold123/X sky130_fd_sc_hd__dlygate4sd3_1
Xhold156 _5887_/Q VGND VGND VPWR VPWR hold156/X sky130_fd_sc_hd__dlygate4sd3_1
Xhold145 _5902_/Q VGND VGND VPWR VPWR _4874_/A sky130_fd_sc_hd__dlygate4sd3_1
X_4446_ _4496_/A _4467_/C _4445_/Y _4499_/A VGND VGND VPWR VPWR _4446_/X sky130_fd_sc_hd__a31o_1
Xhold167 _5511_/Q VGND VGND VPWR VPWR hold167/X sky130_fd_sc_hd__dlygate4sd3_1
Xhold178 _6090_/Q VGND VGND VPWR VPWR hold178/X sky130_fd_sc_hd__dlygate4sd3_1
Xhold189 _6085_/Q VGND VGND VPWR VPWR hold189/X sky130_fd_sc_hd__dlygate4sd3_1
X_4377_ _4364_/A _4364_/C _4364_/B VGND VGND VPWR VPWR _4378_/B sky130_fd_sc_hd__o21bai_1
X_6116_ _6120_/CLK _6116_/D fanout313/X VGND VGND VPWR VPWR _6116_/Q sky130_fd_sc_hd__dfrtp_1
X_3328_ _3747_/C VGND VGND VPWR VPWR _4551_/C sky130_fd_sc_hd__inv_2
XANTENNA__4348__Y _4475_/B VGND VGND VPWR VPWR sky130_fd_sc_hd__diode_2
XANTENNA_fanout184_X _2783_/B VGND VGND VPWR VPWR sky130_fd_sc_hd__diode_2
X_3259_ _3256_/X _3486_/B _4342_/A VGND VGND VPWR VPWR _3268_/C sky130_fd_sc_hd__a21o_1
X_6047_ _6110_/CLK _6047_/D fanout301/X VGND VGND VPWR VPWR _6047_/Q sky130_fd_sc_hd__dfrtp_1
XFILLER_39_561 VGND VGND VPWR VPWR sky130_fd_sc_hd__decap_4
XFILLER_73_339 VGND VGND VPWR VPWR sky130_fd_sc_hd__fill_1
XANTENNA_fanout351_X fanout351/X VGND VGND VPWR VPWR sky130_fd_sc_hd__diode_2
XFILLER_26_233 VGND VGND VPWR VPWR sky130_fd_sc_hd__decap_4
XFILLER_26_277 VGND VGND VPWR VPWR sky130_fd_sc_hd__fill_1
XFILLER_53_69 VGND VGND VPWR VPWR sky130_fd_sc_hd__fill_1
XFILLER_41_225 VGND VGND VPWR VPWR sky130_fd_sc_hd__decap_6
XTAP_TAPCELL_ROW_24_478 VGND VPWR sky130_fd_sc_hd__tapvpwrvgnd_1
XFILLER_10_645 VGND VGND VPWR VPWR sky130_fd_sc_hd__decap_3
XFILLER_6_627 VGND VGND VPWR VPWR sky130_fd_sc_hd__decap_4
XANTENNA__2941__B2 _5520_/Q VGND VGND VPWR VPWR sky130_fd_sc_hd__diode_2
XFILLER_78_44 VGND VGND VPWR VPWR sky130_fd_sc_hd__fill_1
XANTENNA_fanout97_X _5166_/S VGND VGND VPWR VPWR sky130_fd_sc_hd__diode_2
XFILLER_1_321 VGND VGND VPWR VPWR sky130_fd_sc_hd__fill_1
XANTENNA__4539__X _4539_/X VGND VGND VPWR VPWR sky130_fd_sc_hd__diode_2
XANTENNA__4694__A1 _4750_/A1 VGND VGND VPWR VPWR sky130_fd_sc_hd__diode_2
XTAP_TAPCELL_ROW_73_1093 VGND VPWR sky130_fd_sc_hd__tapvpwrvgnd_1
XANTENNA__3715__D_N _4829_/C VGND VGND VPWR VPWR sky130_fd_sc_hd__diode_2
XANTENNA__4997__A2 _5027_/A2 VGND VGND VPWR VPWR sky130_fd_sc_hd__diode_2
XFILLER_45_531 VGND VGND VPWR VPWR sky130_fd_sc_hd__fill_1
XFILLER_72_372 VGND VGND VPWR VPWR sky130_fd_sc_hd__decap_8
XFILLER_32_214 VPWR VGND VPWR VGND sky130_ef_sc_hd__decap_12
XTAP_TAPCELL_ROW_43_721 VGND VPWR sky130_fd_sc_hd__tapvpwrvgnd_1
XANTENNA__4921__A2 _4951_/A2 VGND VGND VPWR VPWR sky130_fd_sc_hd__diode_2
X_4300_ _5715_/Q _4299_/X _4312_/S VGND VGND VPWR VPWR _5715_/D sky130_fd_sc_hd__mux2_1
XFILLER_5_693 VPWR VGND VPWR VGND sky130_ef_sc_hd__decap_12
X_5280_ _6150_/Q _5285_/B VGND VGND VPWR VPWR _5288_/A sky130_fd_sc_hd__or2_1
X_4231_ _5775_/Q _4169_/X _4230_/X _3192_/B VGND VGND VPWR VPWR _4236_/A sky130_fd_sc_hd__o211a_1
XFILLER_4_41 VGND VGND VPWR VPWR sky130_fd_sc_hd__decap_6
XANTENNA__4685__A1 _5767_/Q VGND VGND VPWR VPWR sky130_fd_sc_hd__diode_2
X_4162_ _5701_/Q _3734_/Y _5458_/B VGND VGND VPWR VPWR _4162_/X sky130_fd_sc_hd__o21ba_1
X_4093_ _4093_/A _4315_/B VGND VGND VPWR VPWR _4329_/A sky130_fd_sc_hd__or2_2
X_3113_ _3109_/X _3111_/X _3112_/X VGND VGND VPWR VPWR _3113_/X sky130_fd_sc_hd__o21a_1
X_3044_ _4973_/A0 _2996_/Y _3043_/X VGND VGND VPWR VPWR _3044_/X sky130_fd_sc_hd__a21o_1
XFILLER_70_309 VGND VGND VPWR VPWR sky130_fd_sc_hd__fill_1
XANTENNA__2999__A1 _5487_/Q VGND VGND VPWR VPWR sky130_fd_sc_hd__diode_2
XFILLER_63_372 VPWR VGND VPWR VGND sky130_ef_sc_hd__decap_12
XFILLER_36_586 VGND VGND VPWR VPWR sky130_fd_sc_hd__fill_2
X_4995_ hold401/X _5043_/A2 _4994_/X VGND VGND VPWR VPWR _5943_/D sky130_fd_sc_hd__a21o_1
XANTENNA_fanout144_A _4876_/Y VGND VGND VPWR VPWR sky130_fd_sc_hd__diode_2
XFILLER_23_258 VGND VGND VPWR VPWR sky130_fd_sc_hd__fill_1
X_3946_ _5604_/Q _3544_/X _5353_/A VGND VGND VPWR VPWR _5604_/D sky130_fd_sc_hd__mux2_1
XANTENNA__5583__RESET_B fanout313/X VGND VGND VPWR VPWR sky130_fd_sc_hd__diode_2
XTAP_TAPCELL_ROW_21_437 VGND VPWR sky130_fd_sc_hd__tapvpwrvgnd_1
XTAP_TAPCELL_ROW_21_448 VGND VPWR sky130_fd_sc_hd__tapvpwrvgnd_1
X_3877_ _6174_/Q _3876_/X _3877_/S VGND VGND VPWR VPWR _3877_/X sky130_fd_sc_hd__mux2_1
X_2828_ _5467_/Q _2935_/B _2827_/Y _4964_/A0 VGND VGND VPWR VPWR _2828_/X sky130_fd_sc_hd__o22a_1
XANTENNA_fanout311_A fanout324/X VGND VGND VPWR VPWR sky130_fd_sc_hd__diode_2
X_5616_ _5686_/CLK _5616_/D fanout321/X VGND VGND VPWR VPWR _5616_/Q sky130_fd_sc_hd__dfrtp_1
X_2759_ _6177_/Q VGND VGND VPWR VPWR _2776_/A sky130_fd_sc_hd__inv_2
XANTENNA__4912__A2 _4951_/A2 VGND VGND VPWR VPWR sky130_fd_sc_hd__diode_2
X_5547_ _5682_/CLK _5547_/D VGND VGND VPWR VPWR hold14/A sky130_fd_sc_hd__dfxtp_1
X_5478_ _5966_/CLK _5478_/D fanout305/X VGND VGND VPWR VPWR _5478_/Q sky130_fd_sc_hd__dfrtp_2
X_4429_ _4430_/A _4430_/B _4430_/C VGND VGND VPWR VPWR _4429_/Y sky130_fd_sc_hd__a21oi_1
XTAP_TAPCELL_ROW_29_537 VGND VPWR sky130_fd_sc_hd__tapvpwrvgnd_1
XTAP_TAPCELL_ROW_29_548 VGND VPWR sky130_fd_sc_hd__tapvpwrvgnd_1
XANTENNA_fanout57_A _5123_/B VGND VGND VPWR VPWR sky130_fd_sc_hd__diode_2
XFILLER_73_169 VGND VGND VPWR VPWR sky130_fd_sc_hd__fill_1
XFILLER_64_79 VGND VGND VPWR VPWR sky130_fd_sc_hd__decap_4
XFILLER_14_203 VGND VGND VPWR VPWR sky130_fd_sc_hd__fill_2
XTAP_TAPCELL_ROW_1_195 VGND VPWR sky130_fd_sc_hd__tapvpwrvgnd_1
Xfanout40 _3663_/X VGND VGND VPWR VPWR _4386_/S sky130_fd_sc_hd__clkbuf_2
XANTENNA__4600__B2 _4672_/A1 VGND VGND VPWR VPWR sky130_fd_sc_hd__diode_2
Xfanout51 _4678_/A1 VGND VGND VPWR VPWR _4750_/A1 sky130_fd_sc_hd__clkbuf_4
Xfanout62 _3905_/B VGND VGND VPWR VPWR _3845_/B sky130_fd_sc_hd__buf_2
Xfanout73 _4740_/A2 VGND VGND VPWR VPWR _4166_/C sky130_fd_sc_hd__clkbuf_2
XFILLER_80_78 VGND VGND VPWR VPWR sky130_fd_sc_hd__decap_6
Xfanout95 _4452_/B VGND VGND VPWR VPWR _4439_/B sky130_fd_sc_hd__buf_2
Xfanout84 _3478_/Y VGND VGND VPWR VPWR _4496_/A sky130_fd_sc_hd__buf_2
XTAP_TAPCELL_ROW_75_1122 VGND VPWR sky130_fd_sc_hd__tapvpwrvgnd_1
XANTENNA__3614__A _4428_/A VGND VGND VPWR VPWR sky130_fd_sc_hd__diode_2
XFILLER_49_111 VGND VGND VPWR VPWR sky130_fd_sc_hd__fill_1
XTAP_TAPCELL_ROW_9_295 VGND VPWR sky130_fd_sc_hd__tapvpwrvgnd_1
XFILLER_65_615 VGND VGND VPWR VPWR sky130_fd_sc_hd__fill_1
XANTENNA__5092__A1 _2824_/C VGND VGND VPWR VPWR sky130_fd_sc_hd__diode_2
XANTENNA__4164__B _4164_/B VGND VGND VPWR VPWR sky130_fd_sc_hd__diode_2
X_4780_ _5518_/Q hold250/X _4805_/S VGND VGND VPWR VPWR _5817_/D sky130_fd_sc_hd__mux2_1
X_3800_ _4101_/B _4101_/C _3773_/A VGND VGND VPWR VPWR _3800_/X sky130_fd_sc_hd__a21o_1
X_3731_ _4774_/S _3731_/B VGND VGND VPWR VPWR _3731_/Y sky130_fd_sc_hd__nor2_1
XFILLER_9_240 VGND VGND VPWR VPWR sky130_fd_sc_hd__fill_2
Xclkload10 _6159_/CLK VGND VGND VPWR VPWR clkload10/Y sky130_fd_sc_hd__inv_8
X_3662_ _4539_/B _4539_/A VGND VGND VPWR VPWR _4825_/C sky130_fd_sc_hd__and2b_1
Xclkload21 _3182_/A1 VGND VGND VPWR VPWR clkload21/Y sky130_fd_sc_hd__clkinv_8
Xclkload43 _5952_/CLK VGND VGND VPWR VPWR clkload43/Y sky130_fd_sc_hd__clkinv_8
X_3593_ _3593_/A _3593_/B _3593_/C _3593_/D VGND VGND VPWR VPWR _3661_/A sky130_fd_sc_hd__or4_1
X_5401_ _5402_/A _5402_/C _5402_/B VGND VGND VPWR VPWR _5403_/A sky130_fd_sc_hd__a21oi_1
Xclkload32 _5686_/CLK VGND VGND VPWR VPWR clkload32/Y sky130_fd_sc_hd__clkinv_4
X_5332_ _6158_/Q _5337_/B VGND VGND VPWR VPWR _5332_/Y sky130_fd_sc_hd__nor2_1
XANTENNA__4658__A1 _5797_/Q VGND VGND VPWR VPWR sky130_fd_sc_hd__diode_2
X_5263_ _5258_/A _5257_/B _5255_/X VGND VGND VPWR VPWR _5264_/B sky130_fd_sc_hd__o21ai_1
X_4214_ _5907_/Q _5764_/Q _4232_/S VGND VGND VPWR VPWR _4214_/X sky130_fd_sc_hd__mux2_1
X_5194_ _6115_/Q _2837_/B _4539_/X _5739_/Q VGND VGND VPWR VPWR _6115_/D sky130_fd_sc_hd__a22o_1
X_4145_ _4255_/C _4329_/B VGND VGND VPWR VPWR _4319_/B sky130_fd_sc_hd__nor2_1
XFILLER_68_442 VGND VGND VPWR VPWR sky130_fd_sc_hd__decap_3
XFILLER_55_125 VGND VGND VPWR VPWR sky130_fd_sc_hd__fill_1
XANTENNA__3881__A2 _4865_/A VGND VGND VPWR VPWR sky130_fd_sc_hd__diode_2
XANTENNA__5083__A1 _5494_/Q VGND VGND VPWR VPWR sky130_fd_sc_hd__diode_2
X_4076_ hold92/A _5617_/Q _5686_/Q VGND VGND VPWR VPWR _4076_/Y sky130_fd_sc_hd__o21ai_1
X_3027_ _5909_/Q _2987_/Y _2989_/Y _3026_/X VGND VGND VPWR VPWR _3027_/X sky130_fd_sc_hd__o211a_1
XTAP_TAPCELL_ROW_26_507 VGND VPWR sky130_fd_sc_hd__tapvpwrvgnd_1
XTAP_TAPCELL_ROW_54_849 VGND VPWR sky130_fd_sc_hd__tapvpwrvgnd_1
XANTENNA__4594__A0 _5491_/Q VGND VGND VPWR VPWR sky130_fd_sc_hd__diode_2
X_4978_ _6062_/Q _6097_/Q _4978_/C _4978_/D VGND VGND VPWR VPWR _4978_/X sky130_fd_sc_hd__and4_1
XFILLER_50_15 VPWR VGND VPWR VGND sky130_ef_sc_hd__decap_12
X_3929_ _6129_/D _5362_/B _3930_/C _6128_/D VGND VGND VPWR VPWR _3929_/X sky130_fd_sc_hd__or4b_1
Xclkload4 clkload4/A VGND VGND VPWR VPWR clkload4/Y sky130_fd_sc_hd__inv_8
XANTENNA__3149__A1 _2934_/B VGND VGND VPWR VPWR sky130_fd_sc_hd__diode_2
XFILLER_3_449 VGND VGND VPWR VPWR sky130_fd_sc_hd__decap_8
XFILLER_59_57 VGND VGND VPWR VPWR sky130_fd_sc_hd__decap_3
Xfanout230 _5753_/Q VGND VGND VPWR VPWR _4973_/S sky130_fd_sc_hd__buf_4
Xfanout241 _5745_/Q VGND VGND VPWR VPWR _4487_/A sky130_fd_sc_hd__buf_2
XTAP_TAPCELL_ROW_70_1052 VGND VPWR sky130_fd_sc_hd__tapvpwrvgnd_1
XANTENNA__4964__S _4973_/S VGND VGND VPWR VPWR sky130_fd_sc_hd__diode_2
XTAP_TAPCELL_ROW_6_254 VGND VPWR sky130_fd_sc_hd__tapvpwrvgnd_1
Xfanout274 fanout276/X VGND VGND VPWR VPWR fanout274/X sky130_fd_sc_hd__clkbuf_4
Xfanout252 _4813_/A1 VGND VGND VPWR VPWR _4408_/A sky130_fd_sc_hd__buf_2
Xfanout263 _4052_/S VGND VGND VPWR VPWR _4070_/S sky130_fd_sc_hd__clkbuf_4
XFILLER_75_23 VGND VGND VPWR VPWR sky130_fd_sc_hd__decap_3
Xfanout296 fanout297/X VGND VGND VPWR VPWR fanout296/X sky130_fd_sc_hd__clkbuf_4
XFILLER_47_615 VGND VGND VPWR VPWR sky130_fd_sc_hd__fill_1
Xfanout285 fanout286/X VGND VGND VPWR VPWR fanout285/X sky130_fd_sc_hd__clkbuf_4
XFILLER_74_445 VGND VGND VPWR VPWR sky130_fd_sc_hd__fill_1
XANTENNA__5074__A1 _5523_/Q VGND VGND VPWR VPWR sky130_fd_sc_hd__diode_2
XFILLER_61_117 VGND VGND VPWR VPWR sky130_fd_sc_hd__fill_1
XFILLER_27_361 VGND VGND VPWR VPWR sky130_fd_sc_hd__decap_8
XFILLER_15_589 VGND VGND VPWR VPWR sky130_fd_sc_hd__fill_1
XANTENNA__4585__B1 _4584_/X VGND VGND VPWR VPWR sky130_fd_sc_hd__diode_2
XFILLER_24_93 VGND VGND VPWR VPWR sky130_fd_sc_hd__fill_1
XFILLER_7_711 VGND VGND VPWR VPWR sky130_fd_sc_hd__fill_2
XFILLER_37_147 VGND VGND VPWR VPWR sky130_fd_sc_hd__fill_2
XANTENNA__5065__A1 _5447_/A VGND VGND VPWR VPWR sky130_fd_sc_hd__diode_2
XFILLER_38_659 VGND VGND VPWR VPWR sky130_fd_sc_hd__decap_6
X_5950_ _5952_/CLK _5950_/D fanout334/X VGND VGND VPWR VPWR _5950_/Q sky130_fd_sc_hd__dfrtp_1
X_4901_ _5800_/Q _5524_/Q _4901_/S VGND VGND VPWR VPWR _4901_/X sky130_fd_sc_hd__mux2_1
XFILLER_52_139 VGND VGND VPWR VPWR sky130_fd_sc_hd__fill_1
XANTENNA__4812__A1 _4873_/A VGND VGND VPWR VPWR sky130_fd_sc_hd__diode_2
X_5881_ _6093_/CLK _5881_/D fanout344/X VGND VGND VPWR VPWR _5881_/Q sky130_fd_sc_hd__dfrtp_1
XTAP_TAPCELL_ROW_51_819 VGND VPWR sky130_fd_sc_hd__tapvpwrvgnd_1
XFILLER_33_342 VGND VGND VPWR VPWR sky130_fd_sc_hd__decap_4
XFILLER_60_183 VGND VGND VPWR VPWR sky130_fd_sc_hd__fill_2
X_4832_ _5140_/C _5759_/Q _5758_/Q VGND VGND VPWR VPWR _4832_/X sky130_fd_sc_hd__or3b_1
X_4763_ _4873_/B _3746_/X hold110/X VGND VGND VPWR VPWR _5801_/D sky130_fd_sc_hd__a21o_1
XFILLER_21_559 VGND VGND VPWR VPWR sky130_fd_sc_hd__fill_1
X_4694_ _4750_/A1 _4693_/X _4750_/C1 VGND VGND VPWR VPWR _4694_/X sky130_fd_sc_hd__o21a_1
X_3714_ _3714_/A _3714_/B _3714_/C _3714_/D VGND VGND VPWR VPWR _3716_/C sky130_fd_sc_hd__or4_1
XTAP_TAPCELL_ROW_31_565 VGND VPWR sky130_fd_sc_hd__tapvpwrvgnd_1
X_3645_ _3698_/A _3645_/B _3694_/A _3697_/B VGND VGND VPWR VPWR _3659_/A sky130_fd_sc_hd__or4_1
XFILLER_20_29 VGND VGND VPWR VPWR sky130_fd_sc_hd__decap_4
XANTENNA_fanout107_A _4878_/Y VGND VGND VPWR VPWR sky130_fd_sc_hd__diode_2
XANTENNA__3000__B1 _3138_/B VGND VGND VPWR VPWR sky130_fd_sc_hd__diode_2
X_3576_ _3576_/A _3674_/A _3576_/C _5902_/Q VGND VGND VPWR VPWR _3593_/A sky130_fd_sc_hd__or4b_1
X_5315_ _5315_/A _5315_/B _5315_/C VGND VGND VPWR VPWR _5315_/X sky130_fd_sc_hd__or3_1
X_5246_ _3663_/A _3492_/B _5230_/B _5244_/Y _5353_/B VGND VGND VPWR VPWR _5310_/A
+ sky130_fd_sc_hd__a311o_1
XANTENNA__3254__A _3254_/A VGND VGND VPWR VPWR sky130_fd_sc_hd__diode_2
XANTENNA__4784__S _4810_/S VGND VGND VPWR VPWR sky130_fd_sc_hd__diode_2
XTAP_TAPCELL_ROW_59_919 VGND VPWR sky130_fd_sc_hd__tapvpwrvgnd_1
Xhold16 hold16/A VGND VGND VPWR VPWR hold16/X sky130_fd_sc_hd__dlygate4sd3_1
Xhold27 hold27/A VGND VGND VPWR VPWR hold27/X sky130_fd_sc_hd__dlygate4sd3_1
Xhold38 hold38/A VGND VGND VPWR VPWR hold38/X sky130_fd_sc_hd__dlygate4sd3_1
XANTENNA__3303__A1 _5200_/C VGND VGND VPWR VPWR sky130_fd_sc_hd__diode_2
X_5177_ hold336/X _3651_/B _5185_/S VGND VGND VPWR VPWR _6099_/D sky130_fd_sc_hd__mux2_1
XTAP_TAPCELL_ROW_3_213 VGND VPWR sky130_fd_sc_hd__tapvpwrvgnd_1
Xhold49 hold49/A VGND VGND VPWR VPWR hold49/X sky130_fd_sc_hd__dlygate4sd3_1
XANTENNA__5056__A1 _5200_/C VGND VGND VPWR VPWR sky130_fd_sc_hd__diode_2
X_4128_ _4127_/B _4127_/C _5574_/Q VGND VGND VPWR VPWR _4128_/Y sky130_fd_sc_hd__a21oi_1
X_4059_ _3967_/A _4058_/X _4057_/X _4542_/A VGND VGND VPWR VPWR _4059_/X sky130_fd_sc_hd__a211o_1
XTAP_TAPCELL_ROW_39_665 VGND VPWR sky130_fd_sc_hd__tapvpwrvgnd_1
XANTENNA_fanout264_X _4052_/S VGND VGND VPWR VPWR sky130_fd_sc_hd__diode_2
XFILLER_45_15 VGND VGND VPWR VPWR sky130_fd_sc_hd__decap_4
XFILLER_36_180 VGND VGND VPWR VPWR sky130_fd_sc_hd__decap_4
XFILLER_51_150 VGND VGND VPWR VPWR sky130_fd_sc_hd__fill_1
XFILLER_61_69 VGND VGND VPWR VPWR sky130_fd_sc_hd__decap_6
X_5464__5 _5966_/CLK VGND VGND VPWR VPWR _5733_/CLK sky130_fd_sc_hd__inv_2
XANTENNA__2987__B _4232_/S VGND VGND VPWR VPWR sky130_fd_sc_hd__diode_2
XFILLER_79_559 VGND VGND VPWR VPWR sky130_fd_sc_hd__fill_1
XFILLER_3_279 VGND VGND VPWR VPWR sky130_fd_sc_hd__fill_1
XFILLER_19_60 VGND VGND VPWR VPWR sky130_fd_sc_hd__fill_2
XFILLER_19_71 VGND VGND VPWR VPWR sky130_fd_sc_hd__fill_1
XFILLER_19_136 VGND VGND VPWR VPWR sky130_fd_sc_hd__decap_4
XFILLER_19_169 VGND VGND VPWR VPWR sky130_fd_sc_hd__fill_2
XFILLER_34_106 VGND VGND VPWR VPWR sky130_fd_sc_hd__fill_1
XANTENNA__2805__B1 _2916_/B VGND VGND VPWR VPWR sky130_fd_sc_hd__diode_2
XANTENNA__4558__B1 _3564_/B VGND VGND VPWR VPWR sky130_fd_sc_hd__diode_2
X_3430_ hold85/X _5585_/Q _3434_/S VGND VGND VPWR VPWR _5544_/D sky130_fd_sc_hd__mux2_1
X_3361_ _3361_/A _3361_/B _3361_/C _3361_/D VGND VGND VPWR VPWR _3367_/B sky130_fd_sc_hd__or4_1
X_6080_ _6088_/CLK _6080_/D fanout338/X VGND VGND VPWR VPWR _6080_/Q sky130_fd_sc_hd__dfrtp_1
XPHY_EDGE_ROW_29_Left_110 VGND VGND VPWR VPWR sky130_fd_sc_hd__decap_3
XFILLER_32_3 VGND VGND VPWR VPWR sky130_fd_sc_hd__decap_4
X_5100_ hold416/X _5377_/A _5127_/B VGND VGND VPWR VPWR _6023_/D sky130_fd_sc_hd__mux2_1
X_3292_ _6033_/Q _5447_/A VGND VGND VPWR VPWR _3356_/C sky130_fd_sc_hd__and2b_1
X_5031_ hold393/X _5043_/A2 _5030_/X VGND VGND VPWR VPWR _5961_/D sky130_fd_sc_hd__a21o_1
XFILLER_38_412 VGND VGND VPWR VPWR sky130_fd_sc_hd__decap_8
XFILLER_26_629 VPWR VGND VPWR VGND sky130_ef_sc_hd__decap_12
XANTENNA__4797__A0 _5469_/Q VGND VGND VPWR VPWR sky130_fd_sc_hd__diode_2
XTAP_TAPCELL_ROW_36_624 VGND VPWR sky130_fd_sc_hd__tapvpwrvgnd_1
XTAP_TAPCELL_ROW_36_635 VGND VPWR sky130_fd_sc_hd__tapvpwrvgnd_1
XFILLER_80_256 VGND VGND VPWR VPWR sky130_fd_sc_hd__fill_1
X_5933_ _5966_/CLK _5933_/D fanout305/X VGND VGND VPWR VPWR _5933_/Q sky130_fd_sc_hd__dfrtp_1
XTAP_TAPCELL_ROW_64_977 VGND VPWR sky130_fd_sc_hd__tapvpwrvgnd_1
XANTENNA__3948__S _5353_/A VGND VGND VPWR VPWR sky130_fd_sc_hd__diode_2
X_5864_ _6110_/CLK _5864_/D fanout301/X VGND VGND VPWR VPWR _5864_/Q sky130_fd_sc_hd__dfrtp_1
XTAP_TAPCELL_ROW_16_381 VGND VPWR sky130_fd_sc_hd__tapvpwrvgnd_1
XANTENNA__4352__B _5736_/Q VGND VGND VPWR VPWR sky130_fd_sc_hd__diode_2
X_4815_ _3651_/B _4824_/A2 _4811_/X hold126/X VGND VGND VPWR VPWR _5851_/D sky130_fd_sc_hd__a22o_1
XANTENNA__4549__B1 _3746_/X VGND VGND VPWR VPWR sky130_fd_sc_hd__diode_2
X_5795_ _6111_/CLK _5795_/D fanout327/X VGND VGND VPWR VPWR _5795_/Q sky130_fd_sc_hd__dfrtp_1
X_4746_ _5800_/Q _4973_/A0 _4746_/S VGND VGND VPWR VPWR _4746_/X sky130_fd_sc_hd__mux2_1
X_4677_ _5958_/Q _5766_/Q _4679_/S VGND VGND VPWR VPWR _4677_/X sky130_fd_sc_hd__mux2_1
XANTENNA__6144__RESET_B fanout352/X VGND VGND VPWR VPWR sky130_fd_sc_hd__diode_2
XANTENNA__4779__S _4805_/S VGND VGND VPWR VPWR sky130_fd_sc_hd__diode_2
X_3628_ _4399_/A _5968_/Q _5972_/Q _4452_/A VGND VGND VPWR VPWR _3628_/X sky130_fd_sc_hd__o22a_1
X_3559_ _3557_/Y _3558_/X _3556_/X VGND VGND VPWR VPWR _3559_/Y sky130_fd_sc_hd__o21ai_4
XFILLER_0_249 VGND VGND VPWR VPWR sky130_fd_sc_hd__decap_3
X_5229_ _3530_/A _5235_/B _5231_/B _5228_/X VGND VGND VPWR VPWR _6132_/D sky130_fd_sc_hd__a22o_1
XFILLER_29_434 VPWR VGND VPWR VGND sky130_ef_sc_hd__decap_12
XANTENNA__4788__A0 _5488_/Q VGND VGND VPWR VPWR sky130_fd_sc_hd__diode_2
XFILLER_25_673 VGND VGND VPWR VPWR sky130_fd_sc_hd__decap_8
XANTENNA__3622__A _4517_/A VGND VGND VPWR VPWR sky130_fd_sc_hd__diode_2
XANTENNA_clkload2_A clkload2/A VGND VGND VPWR VPWR sky130_fd_sc_hd__diode_2
XANTENNA__4779__A0 _5517_/Q VGND VGND VPWR VPWR sky130_fd_sc_hd__diode_2
X_2930_ _2930_/A _2930_/B _2930_/C _2930_/D VGND VGND VPWR VPWR _2930_/X sky130_fd_sc_hd__or4_1
XTAP_TAPCELL_ROW_61_947 VGND VPWR sky130_fd_sc_hd__tapvpwrvgnd_1
XANTENNA__3203__A0 _4973_/A0 VGND VGND VPWR VPWR sky130_fd_sc_hd__diode_2
X_4600_ _4596_/X _4598_/X _4599_/X _4672_/A1 _4720_/C1 VGND VGND VPWR VPWR _4600_/X
+ sky130_fd_sc_hd__a221o_1
X_2861_ _5884_/Q _2783_/B _2921_/B1 _5872_/Q VGND VGND VPWR VPWR _2861_/X sky130_fd_sc_hd__a22o_1
XTAP_TAPCELL_ROW_13_340 VGND VPWR sky130_fd_sc_hd__tapvpwrvgnd_1
XFILLER_30_164 VGND VGND VPWR VPWR sky130_fd_sc_hd__decap_4
X_2792_ _2864_/A _2871_/C _2920_/B VGND VGND VPWR VPWR _2792_/Y sky130_fd_sc_hd__nor3b_1
X_5580_ _5707_/CLK _5580_/D fanout289/X VGND VGND VPWR VPWR _5580_/Q sky130_fd_sc_hd__dfrtp_1
XFILLER_30_197 VGND VGND VPWR VPWR sky130_fd_sc_hd__fill_2
XTAP_TAPCELL_ROW_41_693 VGND VPWR sky130_fd_sc_hd__tapvpwrvgnd_1
X_4531_ _4531_/A _4531_/B VGND VGND VPWR VPWR _4531_/Y sky130_fd_sc_hd__xnor2_1
Xhold305 _5882_/Q VGND VGND VPWR VPWR hold305/X sky130_fd_sc_hd__dlygate4sd3_1
Xhold316 _6106_/Q VGND VGND VPWR VPWR hold316/X sky130_fd_sc_hd__dlygate4sd3_1
X_4462_ _4462_/A _4462_/B _4462_/C VGND VGND VPWR VPWR _4462_/X sky130_fd_sc_hd__and3_1
Xhold327 _5879_/Q VGND VGND VPWR VPWR hold327/X sky130_fd_sc_hd__dlygate4sd3_1
X_3413_ hold81/X _5639_/Q _3416_/S VGND VGND VPWR VPWR _5529_/D sky130_fd_sc_hd__mux2_1
Xhold338 _5669_/Q VGND VGND VPWR VPWR _3104_/A sky130_fd_sc_hd__dlygate4sd3_1
Xhold349 _6168_/Q VGND VGND VPWR VPWR hold349/X sky130_fd_sc_hd__dlygate4sd3_1
XANTENNA__4703__A0 _5761_/Q VGND VGND VPWR VPWR sky130_fd_sc_hd__diode_2
X_4393_ _4408_/A _4394_/B VGND VGND VPWR VPWR _4404_/B sky130_fd_sc_hd__or2_1
X_6132_ _6161_/CLK _6132_/D fanout311/X VGND VGND VPWR VPWR _6132_/Q sky130_fd_sc_hd__dfrtp_1
X_3344_ _3361_/A _3361_/B _3361_/C _3367_/A VGND VGND VPWR VPWR _3351_/A sky130_fd_sc_hd__or4_1
X_6063_ _6115_/CLK _6063_/D fanout335/X VGND VGND VPWR VPWR _6063_/Q sky130_fd_sc_hd__dfrtp_1
X_3275_ _5377_/A _6023_/Q VGND VGND VPWR VPWR _3357_/B sky130_fd_sc_hd__and2b_1
X_5014_ _4637_/X _5038_/A2 _5038_/B1 _4931_/X VGND VGND VPWR VPWR _5014_/X sky130_fd_sc_hd__a22o_1
XANTENNA__5520__Q _5520_/Q VGND VGND VPWR VPWR sky130_fd_sc_hd__diode_2
XFILLER_38_242 VGND VGND VPWR VPWR sky130_fd_sc_hd__decap_3
XFILLER_38_253 VPWR VGND VPWR VGND sky130_ef_sc_hd__decap_12
XFILLER_53_212 VGND VGND VPWR VPWR sky130_fd_sc_hd__fill_1
XTAP_TAPCELL_ROW_49_793 VGND VPWR sky130_fd_sc_hd__tapvpwrvgnd_1
X_5916_ _6142_/CLK _5916_/D fanout326/X VGND VGND VPWR VPWR _5916_/Q sky130_fd_sc_hd__dfrtp_1
XANTENNA_fanout341_A fanout352/X VGND VGND VPWR VPWR sky130_fd_sc_hd__diode_2
XANTENNA__4363__A _5737_/Q VGND VGND VPWR VPWR sky130_fd_sc_hd__diode_2
X_5847_ _6094_/CLK _5847_/D fanout349/X VGND VGND VPWR VPWR _5847_/Q sky130_fd_sc_hd__dfrtp_1
XFILLER_42_27 VGND VGND VPWR VPWR sky130_fd_sc_hd__fill_1
X_5778_ _6032_/CLK _5778_/D fanout300/X VGND VGND VPWR VPWR _5778_/Q sky130_fd_sc_hd__dfrtp_1
X_4729_ hold240/X _4745_/A2 _4728_/X VGND VGND VPWR VPWR _5789_/D sky130_fd_sc_hd__o21a_1
XANTENNA__3745__A1 _5754_/Q VGND VGND VPWR VPWR sky130_fd_sc_hd__diode_2
XANTENNA__2787__A_N _2871_/B VGND VGND VPWR VPWR sky130_fd_sc_hd__diode_2
XANTENNA__3426__B _5599_/Q VGND VGND VPWR VPWR sky130_fd_sc_hd__diode_2
XFILLER_67_57 VGND VGND VPWR VPWR sky130_fd_sc_hd__decap_3
XFILLER_17_404 VPWR VGND VPWR VGND sky130_ef_sc_hd__decap_12
XTAP_TAPCELL_ROW_67_1013 VGND VPWR sky130_fd_sc_hd__tapvpwrvgnd_1
XANTENNA__3681__B1 _4873_/A VGND VGND VPWR VPWR sky130_fd_sc_hd__diode_2
XANTENNA__5369__A _5369_/A VGND VGND VPWR VPWR sky130_fd_sc_hd__diode_2
XFILLER_16_83 VGND VGND VPWR VPWR sky130_fd_sc_hd__fill_1
XFILLER_13_665 VGND VGND VPWR VPWR sky130_fd_sc_hd__decap_6
XANTENNA__3562__A_N _3544_/X VGND VGND VPWR VPWR sky130_fd_sc_hd__diode_2
XTAP_TAPCELL_ROW_10_310 VGND VPWR sky130_fd_sc_hd__tapvpwrvgnd_1
XTAP_TAPCELL_ROW_78_1153 VGND VPWR sky130_fd_sc_hd__tapvpwrvgnd_1
X_3060_ _5604_/Q _5653_/Q VGND VGND VPWR VPWR _3060_/Y sky130_fd_sc_hd__nand2_1
XTAP_TAPCELL_ROW_18_410 VGND VPWR sky130_fd_sc_hd__tapvpwrvgnd_1
XTAP_TAPCELL_ROW_46_752 VGND VPWR sky130_fd_sc_hd__tapvpwrvgnd_1
XFILLER_23_407 VGND VGND VPWR VPWR sky130_fd_sc_hd__decap_3
X_5701_ _3182_/A1 _5701_/D _3183_/B VGND VGND VPWR VPWR _5701_/Q sky130_fd_sc_hd__dfrtp_4
XFILLER_16_470 VGND VGND VPWR VPWR sky130_fd_sc_hd__decap_6
X_3962_ _5648_/Q _5686_/Q VGND VGND VPWR VPWR _3978_/A sky130_fd_sc_hd__and2_1
X_2913_ _5827_/Q _2916_/B _2918_/B1 _5839_/Q VGND VGND VPWR VPWR _2913_/X sky130_fd_sc_hd__a22o_1
XANTENNA__6171__Q _6171_/Q VGND VGND VPWR VPWR sky130_fd_sc_hd__diode_2
X_3893_ _5447_/A _3905_/B _3893_/C VGND VGND VPWR VPWR _3893_/X sky130_fd_sc_hd__and3_1
X_2844_ _2834_/C _5472_/Q _2844_/C _2844_/D VGND VGND VPWR VPWR _2844_/X sky130_fd_sc_hd__and4b_1
X_5632_ _5645_/CLK hold5/X VGND VGND VPWR VPWR hold2/A sky130_fd_sc_hd__dfxtp_1
X_5563_ _5696_/CLK _5563_/D VGND VGND VPWR VPWR hold21/A sky130_fd_sc_hd__dfxtp_1
X_2775_ _4320_/A _4320_/B _4138_/A VGND VGND VPWR VPWR _4333_/S sky130_fd_sc_hd__nor3_1
X_4514_ _4511_/X _4513_/X _4357_/X VGND VGND VPWR VPWR _4514_/Y sky130_fd_sc_hd__a21oi_1
X_5494_ _6085_/CLK _5494_/D fanout332/X VGND VGND VPWR VPWR _5494_/Q sky130_fd_sc_hd__dfrtp_4
Xhold102 _5704_/Q VGND VGND VPWR VPWR hold102/X sky130_fd_sc_hd__dlygate4sd3_1
Xhold124 _5709_/Q VGND VGND VPWR VPWR hold124/X sky130_fd_sc_hd__dlygate4sd3_1
XANTENNA__3029__C_N _4970_/A0 VGND VGND VPWR VPWR sky130_fd_sc_hd__diode_2
Xhold113 _5993_/Q VGND VGND VPWR VPWR hold113/X sky130_fd_sc_hd__dlygate4sd3_1
Xhold135 _5806_/Q VGND VGND VPWR VPWR hold135/X sky130_fd_sc_hd__dlygate4sd3_1
XANTENNA__5718__RESET_B fanout313/X VGND VGND VPWR VPWR sky130_fd_sc_hd__diode_2
Xhold157 _6009_/Q VGND VGND VPWR VPWR hold157/X sky130_fd_sc_hd__dlygate4sd3_1
XANTENNA__4688__C1 _4720_/C1 VGND VGND VPWR VPWR sky130_fd_sc_hd__diode_2
Xhold168 _5819_/Q VGND VGND VPWR VPWR hold168/X sky130_fd_sc_hd__dlygate4sd3_1
X_4445_ _4447_/A _4444_/C _4444_/B VGND VGND VPWR VPWR _4445_/Y sky130_fd_sc_hd__o21ai_1
Xhold146 _5510_/Q VGND VGND VPWR VPWR hold146/X sky130_fd_sc_hd__dlygate4sd3_1
Xhold179 _5732_/Q VGND VGND VPWR VPWR hold179/X sky130_fd_sc_hd__dlygate4sd3_1
X_4376_ _4376_/A _4376_/B VGND VGND VPWR VPWR _4378_/A sky130_fd_sc_hd__nor2_1
XANTENNA__3533__Y _3564_/A VGND VGND VPWR VPWR sky130_fd_sc_hd__diode_2
X_3327_ _3299_/X _3303_/X _3308_/X _3326_/X _3295_/X VGND VGND VPWR VPWR _3747_/C
+ sky130_fd_sc_hd__o41a_1
X_6115_ _6115_/CLK _6115_/D fanout335/X VGND VGND VPWR VPWR _6115_/Q sky130_fd_sc_hd__dfrtp_4
XANTENNA_fanout291_A fanout292/X VGND VGND VPWR VPWR sky130_fd_sc_hd__diode_2
XANTENNA__3262__A _6129_/D VGND VGND VPWR VPWR sky130_fd_sc_hd__diode_2
X_3258_ _5217_/A _3472_/A VGND VGND VPWR VPWR _3486_/B sky130_fd_sc_hd__or2_1
X_6046_ _6110_/CLK _6046_/D fanout299/X VGND VGND VPWR VPWR _6046_/Q sky130_fd_sc_hd__dfrtp_1
XANTENNA_fanout177_X _2886_/B VGND VGND VPWR VPWR sky130_fd_sc_hd__diode_2
XANTENNA__4792__S _4810_/S VGND VGND VPWR VPWR sky130_fd_sc_hd__diode_2
X_3189_ _3442_/S _3189_/B VGND VGND VPWR VPWR _5466_/D sky130_fd_sc_hd__or2_1
XANTENNA_clkbuf_leaf_54_clk_A clkload0/A VGND VGND VPWR VPWR sky130_fd_sc_hd__diode_2
XFILLER_14_407 VPWR VGND VPWR VGND sky130_ef_sc_hd__decap_12
XANTENNA__3201__S _3203_/S VGND VGND VPWR VPWR sky130_fd_sc_hd__diode_2
XTAP_TAPCELL_ROW_24_479 VGND VPWR sky130_fd_sc_hd__tapvpwrvgnd_1
XFILLER_6_639 VGND VGND VPWR VPWR sky130_fd_sc_hd__decap_4
XANTENNA__4032__S _4052_/S VGND VGND VPWR VPWR sky130_fd_sc_hd__diode_2
XANTENNA__4967__S _4973_/S VGND VGND VPWR VPWR sky130_fd_sc_hd__diode_2
XTAP_TAPCELL_ROW_73_1094 VGND VPWR sky130_fd_sc_hd__tapvpwrvgnd_1
XFILLER_72_340 VGND VGND VPWR VPWR sky130_fd_sc_hd__fill_1
XFILLER_17_223 VGND VGND VPWR VPWR sky130_fd_sc_hd__fill_1
XFILLER_45_554 VGND VGND VPWR VPWR sky130_fd_sc_hd__decap_6
XANTENNA__3406__A0 _4970_/A0 VGND VGND VPWR VPWR sky130_fd_sc_hd__diode_2
Xclkbuf_2_0__f_clk clkbuf_0_clk/X VGND VGND VPWR VPWR clkload0/A sky130_fd_sc_hd__clkbuf_16
XFILLER_72_395 VGND VGND VPWR VPWR sky130_fd_sc_hd__fill_1
XFILLER_60_546 VGND VGND VPWR VPWR sky130_fd_sc_hd__decap_3
XFILLER_32_226 VPWR VGND VPWR VGND sky130_ef_sc_hd__decap_12
XTAP_TAPCELL_ROW_43_722 VGND VPWR sky130_fd_sc_hd__tapvpwrvgnd_1
XFILLER_32_259 VPWR VGND VPWR VGND sky130_ef_sc_hd__decap_12
XFILLER_9_411 VGND VGND VPWR VPWR sky130_fd_sc_hd__fill_1
X_4230_ _5791_/Q _4167_/Y _4170_/Y _5783_/Q _4168_/Y VGND VGND VPWR VPWR _4230_/X
+ sky130_fd_sc_hd__a221o_1
XFILLER_4_193 VGND VGND VPWR VPWR sky130_fd_sc_hd__decap_3
X_4161_ _5699_/Q _4138_/A _5459_/B _4160_/X VGND VGND VPWR VPWR _4161_/X sky130_fd_sc_hd__o211a_1
XFILLER_4_53 VGND VGND VPWR VPWR sky130_fd_sc_hd__decap_6
X_4092_ _5723_/Q _5722_/Q VGND VGND VPWR VPWR _4315_/B sky130_fd_sc_hd__nand2b_1
X_3112_ _5676_/Q _5592_/Q _2958_/X _5601_/Q _5590_/Q VGND VGND VPWR VPWR _3112_/X
+ sky130_fd_sc_hd__a221o_1
X_3043_ _5494_/Q _4610_/S _4682_/S _5474_/Q _4879_/B VGND VGND VPWR VPWR _3043_/X
+ sky130_fd_sc_hd__a221o_1
XANTENNA__2999__A2 _5467_/Q VGND VGND VPWR VPWR sky130_fd_sc_hd__diode_2
XFILLER_63_384 VGND VGND VPWR VPWR sky130_fd_sc_hd__decap_4
X_4994_ _4241_/X _5038_/A2 _5038_/B1 _4901_/X VGND VGND VPWR VPWR _4994_/X sky130_fd_sc_hd__a22o_1
X_3945_ _5603_/Q _3548_/Y _5353_/A VGND VGND VPWR VPWR _5603_/D sky130_fd_sc_hd__mux2_1
XTAP_TAPCELL_ROW_21_438 VGND VPWR sky130_fd_sc_hd__tapvpwrvgnd_1
X_3876_ _3900_/A _5858_/Q _3725_/C _4522_/B VGND VGND VPWR VPWR _3876_/X sky130_fd_sc_hd__a22o_1
XFILLER_31_281 VGND VGND VPWR VPWR sky130_fd_sc_hd__fill_2
X_5615_ _5686_/CLK _5615_/D fanout322/X VGND VGND VPWR VPWR _5615_/Q sky130_fd_sc_hd__dfrtp_1
X_2827_ _2833_/A _2934_/A _2842_/B VGND VGND VPWR VPWR _2827_/Y sky130_fd_sc_hd__nand3_1
X_5546_ _5686_/CLK _5546_/D VGND VGND VPWR VPWR hold25/A sky130_fd_sc_hd__dfxtp_1
X_2758_ _6032_/Q VGND VGND VPWR VPWR _2758_/Y sky130_fd_sc_hd__inv_2
X_5477_ _5966_/CLK _5477_/D fanout305/X VGND VGND VPWR VPWR _5477_/Q sky130_fd_sc_hd__dfrtp_2
XANTENNA__2923__A2 _2895_/C VGND VGND VPWR VPWR sky130_fd_sc_hd__diode_2
X_4428_ _4428_/A _4439_/B VGND VGND VPWR VPWR _4430_/C sky130_fd_sc_hd__xnor2_1
XANTENNA__3544__X _3544_/X VGND VGND VPWR VPWR sky130_fd_sc_hd__diode_2
XANTENNA__4676__A2 _4748_/A2 VGND VGND VPWR VPWR sky130_fd_sc_hd__diode_2
XFILLER_48_15 VGND VGND VPWR VPWR sky130_fd_sc_hd__fill_2
XFILLER_48_26 VGND VGND VPWR VPWR sky130_fd_sc_hd__fill_2
X_4359_ _5737_/Q _4475_/B VGND VGND VPWR VPWR _4359_/Y sky130_fd_sc_hd__nand2_1
X_6029_ clkload6/A _6029_/D fanout284/X VGND VGND VPWR VPWR _6029_/Q sky130_fd_sc_hd__dfrtp_1
XFILLER_46_329 VGND VGND VPWR VPWR sky130_fd_sc_hd__fill_1
XFILLER_64_25 VGND VGND VPWR VPWR sky130_fd_sc_hd__decap_3
XTAP_TAPCELL_ROW_29_538 VGND VPWR sky130_fd_sc_hd__tapvpwrvgnd_1
XTAP_TAPCELL_ROW_1_196 VGND VPWR sky130_fd_sc_hd__tapvpwrvgnd_1
XFILLER_42_535 VGND VGND VPWR VPWR sky130_fd_sc_hd__fill_1
XFILLER_14_248 VGND VGND VPWR VPWR sky130_fd_sc_hd__decap_4
Xfanout30 _3764_/X VGND VGND VPWR VPWR _3783_/A sky130_fd_sc_hd__clkbuf_4
Xfanout41 _4561_/Y VGND VGND VPWR VPWR _4667_/B1 sky130_fd_sc_hd__clkbuf_4
Xfanout52 _4678_/A1 VGND VGND VPWR VPWR _4686_/A1 sky130_fd_sc_hd__clkbuf_4
Xfanout74 _3330_/X VGND VGND VPWR VPWR _4740_/A2 sky130_fd_sc_hd__clkbuf_2
Xfanout63 _3880_/B VGND VGND VPWR VPWR _3905_/B sky130_fd_sc_hd__buf_2
Xfanout96 _4344_/X VGND VGND VPWR VPWR _4452_/B sky130_fd_sc_hd__buf_2
Xfanout85 _3478_/Y VGND VGND VPWR VPWR _4354_/S sky130_fd_sc_hd__clkbuf_2
XTAP_TAPCELL_ROW_75_1123 VGND VPWR sky130_fd_sc_hd__tapvpwrvgnd_1
XTAP_TAPCELL_ROW_75_1112 VGND VPWR sky130_fd_sc_hd__tapvpwrvgnd_1
XFILLER_2_642 VGND VGND VPWR VPWR sky130_fd_sc_hd__fill_2
XANTENNA__4667__A2 _4747_/A2 VGND VGND VPWR VPWR sky130_fd_sc_hd__diode_2
XTAP_TAPCELL_ROW_9_296 VGND VPWR sky130_fd_sc_hd__tapvpwrvgnd_1
XFILLER_1_185 VGND VGND VPWR VPWR sky130_fd_sc_hd__fill_2
XFILLER_38_70 VGND VGND VPWR VPWR sky130_fd_sc_hd__fill_1
XANTENNA__3630__A _4447_/B VGND VGND VPWR VPWR sky130_fd_sc_hd__diode_2
XFILLER_60_332 VGND VGND VPWR VPWR sky130_fd_sc_hd__fill_1
XTAP_TAPCELL_ROW_56_880 VGND VPWR sky130_fd_sc_hd__tapvpwrvgnd_1
XFILLER_18_598 VGND VGND VPWR VPWR sky130_fd_sc_hd__decap_4
XFILLER_21_708 VGND VGND VPWR VPWR sky130_fd_sc_hd__decap_4
XFILLER_33_557 VGND VGND VPWR VPWR sky130_fd_sc_hd__decap_3
XFILLER_60_398 VGND VGND VPWR VPWR sky130_fd_sc_hd__fill_1
XFILLER_60_376 VGND VGND VPWR VPWR sky130_fd_sc_hd__decap_8
X_3730_ _4774_/S _3731_/B VGND VGND VPWR VPWR _3730_/X sky130_fd_sc_hd__or2_1
XFILLER_9_230 VGND VGND VPWR VPWR sky130_fd_sc_hd__decap_4
XFILLER_13_281 VPWR VGND VPWR VGND sky130_ef_sc_hd__decap_12
X_3661_ _3661_/A _3661_/B _3661_/C _3661_/D VGND VGND VPWR VPWR _4539_/B sky130_fd_sc_hd__nand4_1
Xclkload44 _6021_/CLK VGND VGND VPWR VPWR clkload44/Y sky130_fd_sc_hd__bufinv_16
Xclkload22 _5788_/CLK VGND VGND VPWR VPWR clkload22/Y sky130_fd_sc_hd__clkinv_8
XFILLER_62_3 VPWR VGND VPWR VGND sky130_ef_sc_hd__decap_12
X_3592_ _6108_/Q _4530_/A _3711_/B _3710_/A _3591_/X VGND VGND VPWR VPWR _3593_/D
+ sky130_fd_sc_hd__a2111o_1
Xclkload11 _6061_/CLK VGND VGND VPWR VPWR clkload11/Y sky130_fd_sc_hd__clkinv_8
Xclkload33 _5682_/CLK VGND VGND VPWR VPWR clkload33/Y sky130_fd_sc_hd__inv_8
X_5400_ _5387_/A _5387_/B _5390_/X _5385_/A VGND VGND VPWR VPWR _5402_/C sky130_fd_sc_hd__a211o_1
X_5331_ _6158_/Q _5342_/B _5330_/Y VGND VGND VPWR VPWR _5331_/X sky130_fd_sc_hd__o21ba_1
X_5262_ _5260_/X _5262_/B VGND VGND VPWR VPWR _5264_/A sky130_fd_sc_hd__and2b_1
XFILLER_68_410 VGND VGND VPWR VPWR sky130_fd_sc_hd__fill_1
X_4213_ _5773_/Q _4169_/X _4212_/X _3192_/B VGND VGND VPWR VPWR _4218_/A sky130_fd_sc_hd__o211a_1
X_5193_ _6114_/Q _2837_/B _4539_/X _4829_/C VGND VGND VPWR VPWR _6114_/D sky130_fd_sc_hd__a22o_1
X_4144_ _4247_/A _4093_/A _4137_/Y _4142_/X VGND VGND VPWR VPWR _5458_/B sky130_fd_sc_hd__o211ai_4
XFILLER_28_307 VGND VGND VPWR VPWR sky130_fd_sc_hd__fill_1
X_4075_ hold87/X _3977_/C _4074_/X _4542_/A VGND VGND VPWR VPWR _5667_/D sky130_fd_sc_hd__o22a_1
X_3026_ _5917_/Q _2988_/B _3127_/B _3025_/X VGND VGND VPWR VPWR _3026_/X sky130_fd_sc_hd__a211o_1
XTAP_TAPCELL_ROW_26_508 VGND VPWR sky130_fd_sc_hd__tapvpwrvgnd_1
XFILLER_36_351 VGND VGND VPWR VPWR sky130_fd_sc_hd__fill_1
XFILLER_36_362 VGND VGND VPWR VPWR sky130_fd_sc_hd__fill_2
XFILLER_70_129 VGND VGND VPWR VPWR sky130_fd_sc_hd__decap_8
XANTENNA_fanout254_A _4829_/C VGND VGND VPWR VPWR sky130_fd_sc_hd__diode_2
XFILLER_34_39 VGND VGND VPWR VPWR sky130_fd_sc_hd__decap_4
XANTENNA__4594__A1 _5797_/Q VGND VGND VPWR VPWR sky130_fd_sc_hd__diode_2
X_4977_ _4977_/A _4978_/D VGND VGND VPWR VPWR _4977_/Y sky130_fd_sc_hd__nor2_1
X_3928_ _3928_/A _3928_/B VGND VGND VPWR VPWR _3928_/X sky130_fd_sc_hd__or2_1
Xclkload5 clkload5/A VGND VGND VPWR VPWR clkload5/Y sky130_fd_sc_hd__inv_8
X_3859_ _5575_/Q _5576_/Q _3859_/C VGND VGND VPWR VPWR _3883_/C sky130_fd_sc_hd__and3_1
XFILLER_50_27 VGND VGND VPWR VPWR sky130_fd_sc_hd__fill_1
XANTENNA_fanout307_X fanout307/X VGND VGND VPWR VPWR sky130_fd_sc_hd__diode_2
X_5529_ _6149_/CLK _5529_/D VGND VGND VPWR VPWR hold81/A sky130_fd_sc_hd__dfxtp_1
XANTENNA__3715__A _4408_/A VGND VGND VPWR VPWR sky130_fd_sc_hd__diode_2
XFILLER_59_421 VGND VGND VPWR VPWR sky130_fd_sc_hd__fill_1
Xfanout220 _2842_/B VGND VGND VPWR VPWR _2834_/C sky130_fd_sc_hd__buf_2
Xfanout231 _5750_/Q VGND VGND VPWR VPWR _4536_/A sky130_fd_sc_hd__buf_2
XTAP_TAPCELL_ROW_70_1053 VGND VPWR sky130_fd_sc_hd__tapvpwrvgnd_1
XTAP_TAPCELL_ROW_6_255 VGND VPWR sky130_fd_sc_hd__tapvpwrvgnd_1
Xfanout253 _5739_/Q VGND VGND VPWR VPWR _4813_/A1 sky130_fd_sc_hd__clkbuf_2
Xfanout242 _2744_/A VGND VGND VPWR VPWR _4467_/A sky130_fd_sc_hd__buf_2
Xfanout264 _5614_/Q VGND VGND VPWR VPWR _4052_/S sky130_fd_sc_hd__clkbuf_4
Xfanout297 fanout298/X VGND VGND VPWR VPWR fanout297/X sky130_fd_sc_hd__clkbuf_4
Xfanout275 fanout276/X VGND VGND VPWR VPWR fanout275/X sky130_fd_sc_hd__clkbuf_2
Xfanout286 fanout287/X VGND VGND VPWR VPWR fanout286/X sky130_fd_sc_hd__buf_2
XFILLER_75_68 VPWR VGND VPWR VGND sky130_ef_sc_hd__decap_12
XFILLER_75_57 VGND VGND VPWR VPWR sky130_fd_sc_hd__decap_8
XANTENNA__5141__S _5166_/S VGND VGND VPWR VPWR sky130_fd_sc_hd__diode_2
XFILLER_15_524 VGND VGND VPWR VPWR sky130_fd_sc_hd__fill_2
XFILLER_27_384 VGND VGND VPWR VPWR sky130_fd_sc_hd__decap_8
XFILLER_15_546 VGND VGND VPWR VPWR sky130_fd_sc_hd__decap_6
XFILLER_30_505 VPWR VGND VPWR VGND sky130_ef_sc_hd__decap_12
XANTENNA__5377__A _5377_/A VGND VGND VPWR VPWR sky130_fd_sc_hd__diode_2
XFILLER_10_251 VGND VGND VPWR VPWR sky130_fd_sc_hd__fill_1
XANTENNA__3609__B _3647_/A VGND VGND VPWR VPWR sky130_fd_sc_hd__diode_2
XFILLER_18_351 VGND VGND VPWR VPWR sky130_fd_sc_hd__fill_1
X_4900_ _5909_/Q _4975_/A2 _4899_/X VGND VGND VPWR VPWR _5909_/D sky130_fd_sc_hd__a21o_1
X_5880_ _6088_/CLK _5880_/D fanout340/X VGND VGND VPWR VPWR _5880_/Q sky130_fd_sc_hd__dfrtp_1
X_4831_ hold381/X _3396_/A _3783_/A _5719_/Q VGND VGND VPWR VPWR _5866_/D sky130_fd_sc_hd__a22o_1
XFILLER_33_354 VGND VGND VPWR VPWR sky130_fd_sc_hd__fill_1
XFILLER_21_527 VGND VGND VPWR VPWR sky130_fd_sc_hd__fill_1
XANTENNA__4576__A1 _4672_/A1 VGND VGND VPWR VPWR sky130_fd_sc_hd__diode_2
X_4762_ _4873_/A _4873_/B _4762_/C VGND VGND VPWR VPWR _5051_/S sky130_fd_sc_hd__nand3_1
XANTENNA__3379__A2 _3396_/A VGND VGND VPWR VPWR sky130_fd_sc_hd__diode_2
X_4693_ _5760_/Q _5960_/Q _4751_/S VGND VGND VPWR VPWR _4693_/X sky130_fd_sc_hd__mux2_1
X_3713_ _3713_/A _3713_/B _3713_/C _3713_/D VGND VGND VPWR VPWR _3716_/B sky130_fd_sc_hd__or4_1
XTAP_TAPCELL_ROW_31_566 VGND VPWR sky130_fd_sc_hd__tapvpwrvgnd_1
XANTENNA__4328__B2 _4331_/A1 VGND VGND VPWR VPWR sky130_fd_sc_hd__diode_2
X_3644_ _4399_/A _6035_/Q VGND VGND VPWR VPWR _3697_/B sky130_fd_sc_hd__and2_1
X_3575_ _3573_/Y _3574_/X _3708_/C VGND VGND VPWR VPWR _3576_/C sky130_fd_sc_hd__a21o_1
X_5314_ _6154_/Q _6153_/Q _5343_/B VGND VGND VPWR VPWR _5315_/C sky130_fd_sc_hd__o21a_1
XANTENNA__5523__Q _5523_/Q VGND VGND VPWR VPWR sky130_fd_sc_hd__diode_2
X_5245_ _4344_/D _5247_/B _4344_/A VGND VGND VPWR VPWR _5245_/Y sky130_fd_sc_hd__a21oi_1
Xhold28 hold28/A VGND VGND VPWR VPWR hold28/X sky130_fd_sc_hd__dlygate4sd3_1
Xhold17 hold17/A VGND VGND VPWR VPWR hold17/X sky130_fd_sc_hd__dlygate4sd3_1
XFILLER_68_251 VGND VGND VPWR VPWR sky130_fd_sc_hd__fill_1
X_5176_ hold366/X _4404_/A _5185_/S VGND VGND VPWR VPWR _6098_/D sky130_fd_sc_hd__mux2_1
Xhold39 hold39/A VGND VGND VPWR VPWR hold39/X sky130_fd_sc_hd__dlygate4sd3_1
XTAP_TAPCELL_ROW_3_214 VGND VPWR sky130_fd_sc_hd__tapvpwrvgnd_1
XANTENNA__3541__Y _3541_/Y VGND VGND VPWR VPWR sky130_fd_sc_hd__diode_2
X_4127_ _5574_/Q _4127_/B _4127_/C VGND VGND VPWR VPWR _4127_/X sky130_fd_sc_hd__and3_1
XANTENNA__3270__A _5201_/B VGND VGND VPWR VPWR sky130_fd_sc_hd__diode_2
X_4058_ hold35/A hold76/A _4070_/S VGND VGND VPWR VPWR _4058_/X sky130_fd_sc_hd__mux2_1
XTAP_TAPCELL_ROW_39_666 VGND VPWR sky130_fd_sc_hd__tapvpwrvgnd_1
XFILLER_71_449 VGND VGND VPWR VPWR sky130_fd_sc_hd__decap_4
X_3009_ hold359/X _3008_/X _3114_/S VGND VGND VPWR VPWR _6119_/D sky130_fd_sc_hd__mux2_1
XANTENNA_fanout257_X _5094_/A1 VGND VGND VPWR VPWR sky130_fd_sc_hd__diode_2
XFILLER_61_15 VGND VGND VPWR VPWR sky130_fd_sc_hd__fill_2
XANTENNA__4567__A1 _5760_/Q VGND VGND VPWR VPWR sky130_fd_sc_hd__diode_2
XFILLER_61_37 VGND VGND VPWR VPWR sky130_fd_sc_hd__decap_4
XFILLER_3_225 VGND VGND VPWR VPWR sky130_fd_sc_hd__decap_8
XANTENNA__4040__S _4052_/S VGND VGND VPWR VPWR sky130_fd_sc_hd__diode_2
Xclkbuf_leaf_54_clk clkload0/A VGND VGND VPWR VPWR _6107_/CLK sky130_fd_sc_hd__clkbuf_8
XFILLER_15_332 VGND VGND VPWR VPWR sky130_fd_sc_hd__decap_4
XFILLER_70_482 VGND VGND VPWR VPWR sky130_fd_sc_hd__fill_1
XFILLER_30_302 VGND VGND VPWR VPWR sky130_fd_sc_hd__fill_1
XANTENNA__4558__A1 _5766_/Q VGND VGND VPWR VPWR sky130_fd_sc_hd__diode_2
XFILLER_7_597 VGND VGND VPWR VPWR sky130_fd_sc_hd__fill_1
XANTENNA__4730__A1 _4967_/A0 VGND VGND VPWR VPWR sky130_fd_sc_hd__diode_2
X_3360_ _3360_/A _3360_/B _3360_/C _3360_/D VGND VGND VPWR VPWR _3361_/D sky130_fd_sc_hd__or4_1
X_5030_ _4701_/X _5038_/A2 _5038_/B1 _4955_/X VGND VGND VPWR VPWR _5030_/X sky130_fd_sc_hd__a22o_1
X_3291_ _3749_/A hold91/A VGND VGND VPWR VPWR _3291_/Y sky130_fd_sc_hd__nand2_1
XFILLER_25_3 VGND VGND VPWR VPWR sky130_fd_sc_hd__decap_6
XFILLER_65_210 VGND VGND VPWR VPWR sky130_fd_sc_hd__decap_6
XANTENNA__5038__A2 _5038_/A2 VGND VGND VPWR VPWR sky130_fd_sc_hd__diode_2
XFILLER_38_479 VGND VGND VPWR VPWR sky130_fd_sc_hd__fill_1
X_5932_ _6032_/CLK _5932_/D fanout300/X VGND VGND VPWR VPWR _5932_/Q sky130_fd_sc_hd__dfrtp_1
XTAP_TAPCELL_ROW_36_625 VGND VPWR sky130_fd_sc_hd__tapvpwrvgnd_1
XTAP_TAPCELL_ROW_36_636 VGND VPWR sky130_fd_sc_hd__tapvpwrvgnd_1
XANTENNA__6174__Q _6174_/Q VGND VGND VPWR VPWR sky130_fd_sc_hd__diode_2
XTAP_TAPCELL_ROW_64_978 VGND VPWR sky130_fd_sc_hd__tapvpwrvgnd_1
Xclkbuf_leaf_45_clk clkload1/A VGND VGND VPWR VPWR _6149_/CLK sky130_fd_sc_hd__clkbuf_8
XFILLER_34_652 VGND VGND VPWR VPWR sky130_fd_sc_hd__fill_1
X_5863_ _6097_/CLK _5863_/D fanout301/X VGND VGND VPWR VPWR _5863_/Q sky130_fd_sc_hd__dfrtp_1
XTAP_TAPCELL_ROW_16_382 VGND VPWR sky130_fd_sc_hd__tapvpwrvgnd_1
XFILLER_21_335 VGND VGND VPWR VPWR sky130_fd_sc_hd__fill_1
X_4814_ _4404_/A _4823_/A2 _4824_/B1 hold125/X VGND VGND VPWR VPWR _5850_/D sky130_fd_sc_hd__a22o_1
XFILLER_33_173 VGND VGND VPWR VPWR sky130_fd_sc_hd__fill_1
X_5794_ _6111_/CLK _5794_/D fanout327/X VGND VGND VPWR VPWR _5794_/Q sky130_fd_sc_hd__dfrtp_1
X_4745_ hold284/X _4745_/A2 _4744_/X VGND VGND VPWR VPWR _5791_/D sky130_fd_sc_hd__o21a_1
XFILLER_31_29 VGND VGND VPWR VPWR sky130_fd_sc_hd__fill_1
X_4676_ _5958_/Q _4748_/A2 _4684_/B1 _4675_/X VGND VGND VPWR VPWR _4676_/X sky130_fd_sc_hd__a211o_1
X_3627_ _4399_/A _5968_/Q VGND VGND VPWR VPWR _3680_/B sky130_fd_sc_hd__nand2_1
XANTENNA__3265__A _6130_/D VGND VGND VPWR VPWR sky130_fd_sc_hd__diode_2
X_3558_ _3516_/X _3522_/X _3523_/Y _3549_/A VGND VGND VPWR VPWR _3558_/X sky130_fd_sc_hd__a31o_1
X_3489_ _6133_/Q _3495_/A VGND VGND VPWR VPWR _3567_/B sky130_fd_sc_hd__nand2_1
X_5228_ _5228_/A _5228_/B VGND VGND VPWR VPWR _5228_/X sky130_fd_sc_hd__or2_1
X_5159_ hold177/X _5469_/Q _5167_/S VGND VGND VPWR VPWR _6081_/D sky130_fd_sc_hd__mux2_1
XFILLER_56_15 VGND VGND VPWR VPWR sky130_fd_sc_hd__decap_3
XFILLER_29_446 VGND VGND VPWR VPWR sky130_fd_sc_hd__fill_2
XFILLER_56_287 VGND VGND VPWR VPWR sky130_fd_sc_hd__fill_1
XANTENNA__2799__B1 _2918_/B1 VGND VGND VPWR VPWR sky130_fd_sc_hd__diode_2
Xclkbuf_leaf_36_clk clkload1/A VGND VGND VPWR VPWR _6120_/CLK sky130_fd_sc_hd__clkbuf_8
XFILLER_72_58 VGND VGND VPWR VPWR sky130_fd_sc_hd__decap_8
XFILLER_72_47 VGND VGND VPWR VPWR sky130_fd_sc_hd__decap_3
XFILLER_40_699 VGND VGND VPWR VPWR sky130_fd_sc_hd__fill_1
XANTENNA__4712__B2 _4226_/S VGND VGND VPWR VPWR sky130_fd_sc_hd__diode_2
XANTENNA__5390__A _6167_/Q VGND VGND VPWR VPWR sky130_fd_sc_hd__diode_2
Xclkbuf_leaf_27_clk clkload2/A VGND VGND VPWR VPWR _6094_/CLK sky130_fd_sc_hd__clkbuf_8
XFILLER_28_490 VGND VGND VPWR VPWR sky130_fd_sc_hd__decap_8
XTAP_TAPCELL_ROW_61_937 VGND VPWR sky130_fd_sc_hd__tapvpwrvgnd_1
XTAP_TAPCELL_ROW_61_948 VGND VPWR sky130_fd_sc_hd__tapvpwrvgnd_1
X_2860_ _5876_/Q _2928_/A2 _2927_/B1 _5888_/Q _2859_/X VGND VGND VPWR VPWR _2860_/X
+ sky130_fd_sc_hd__a221o_1
XTAP_TAPCELL_ROW_13_341 VGND VPWR sky130_fd_sc_hd__tapvpwrvgnd_1
XFILLER_30_132 VGND VGND VPWR VPWR sky130_fd_sc_hd__decap_3
XANTENNA__3203__A1 _5474_/Q VGND VGND VPWR VPWR sky130_fd_sc_hd__diode_2
X_2791_ _2925_/B _2920_/B _2925_/D VGND VGND VPWR VPWR _2791_/X sky130_fd_sc_hd__and3b_1
XTAP_TAPCELL_ROW_41_694 VGND VPWR sky130_fd_sc_hd__tapvpwrvgnd_1
XANTENNA__3754__A2 _4865_/A VGND VGND VPWR VPWR sky130_fd_sc_hd__diode_2
XFILLER_11_390 VGND VGND VPWR VPWR sky130_fd_sc_hd__fill_2
XFILLER_7_64 VGND VGND VPWR VPWR sky130_fd_sc_hd__fill_2
X_4530_ _4530_/A _4530_/B VGND VGND VPWR VPWR _4531_/B sky130_fd_sc_hd__xnor2_1
Xhold317 _5897_/Q VGND VGND VPWR VPWR hold317/X sky130_fd_sc_hd__dlygate4sd3_1
Xhold306 _5885_/Q VGND VGND VPWR VPWR hold306/X sky130_fd_sc_hd__dlygate4sd3_1
X_4461_ _4487_/C _4460_/Y _4436_/S VGND VGND VPWR VPWR _4462_/C sky130_fd_sc_hd__o21ai_1
Xhold328 _5787_/Q VGND VGND VPWR VPWR hold328/X sky130_fd_sc_hd__dlygate4sd3_1
X_3412_ hold18/X _5638_/Q _3416_/S VGND VGND VPWR VPWR _5528_/D sky130_fd_sc_hd__mux2_1
Xhold339 _3107_/X VGND VGND VPWR VPWR _5684_/D sky130_fd_sc_hd__dlygate4sd3_1
X_6131_ _6131_/CLK _6131_/D fanout328/X VGND VGND VPWR VPWR _6131_/Q sky130_fd_sc_hd__dfstp_1
X_4392_ _4392_/A _4392_/B VGND VGND VPWR VPWR _4392_/Y sky130_fd_sc_hd__xnor2_1
X_3343_ _3343_/A _3343_/B VGND VGND VPWR VPWR _3367_/A sky130_fd_sc_hd__or2_1
X_3274_ _3905_/A _6034_/Q VGND VGND VPWR VPWR _3356_/B sky130_fd_sc_hd__and2b_1
X_6062_ _6097_/CLK _6062_/D fanout325/X VGND VGND VPWR VPWR _6062_/Q sky130_fd_sc_hd__dfrtp_1
X_5013_ hold443/X _5025_/A2 _5012_/X VGND VGND VPWR VPWR _5952_/D sky130_fd_sc_hd__a21o_1
XFILLER_38_210 VGND VGND VPWR VPWR sky130_fd_sc_hd__decap_4
XTAP_TAPCELL_ROW_49_794 VGND VPWR sky130_fd_sc_hd__tapvpwrvgnd_1
XFILLER_38_265 VGND VGND VPWR VPWR sky130_fd_sc_hd__decap_8
Xclkbuf_leaf_18_clk clkbuf_leaf_9_clk/A VGND VGND VPWR VPWR _5967_/CLK sky130_fd_sc_hd__clkbuf_8
XPHY_EDGE_ROW_5_Right_5 VGND VGND VPWR VPWR sky130_fd_sc_hd__decap_3
X_5915_ _5952_/CLK _5915_/D fanout330/X VGND VGND VPWR VPWR _5915_/Q sky130_fd_sc_hd__dfrtp_1
X_5846_ _6093_/CLK _5846_/D fanout345/X VGND VGND VPWR VPWR _5846_/Q sky130_fd_sc_hd__dfrtp_1
XANTENNA_fanout334_A fanout352/X VGND VGND VPWR VPWR sky130_fd_sc_hd__diode_2
XFILLER_22_666 VGND VGND VPWR VPWR sky130_fd_sc_hd__decap_8
X_5777_ _5788_/CLK _5777_/D fanout297/X VGND VGND VPWR VPWR _5777_/Q sky130_fd_sc_hd__dfrtp_1
X_2989_ _4175_/A _5935_/Q VGND VGND VPWR VPWR _2989_/Y sky130_fd_sc_hd__nor2_2
X_4728_ _4235_/S _4727_/X _4726_/X _3877_/S VGND VGND VPWR VPWR _4728_/X sky130_fd_sc_hd__a211o_1
XANTENNA_fanout122_X _5038_/B1 VGND VGND VPWR VPWR sky130_fd_sc_hd__diode_2
XFILLER_5_309 VPWR VGND VPWR VGND sky130_ef_sc_hd__decap_12
X_4659_ _5923_/Q _4747_/A2 _4667_/B1 _4658_/X VGND VGND VPWR VPWR _4659_/X sky130_fd_sc_hd__a22o_1
XFILLER_57_541 VGND VGND VPWR VPWR sky130_fd_sc_hd__fill_1
XPHY_EDGE_ROW_48_Left_129 VGND VGND VPWR VPWR sky130_fd_sc_hd__decap_3
XTAP_TAPCELL_ROW_67_1014 VGND VPWR sky130_fd_sc_hd__tapvpwrvgnd_1
XANTENNA__3681__A1 _4464_/A VGND VGND VPWR VPWR sky130_fd_sc_hd__diode_2
XFILLER_17_416 VGND VGND VPWR VPWR sky130_fd_sc_hd__fill_1
XFILLER_44_213 VGND VGND VPWR VPWR sky130_fd_sc_hd__fill_1
XFILLER_17_449 VGND VGND VPWR VPWR sky130_fd_sc_hd__fill_1
XFILLER_44_246 VGND VGND VPWR VPWR sky130_fd_sc_hd__decap_4
XFILLER_32_419 VGND VGND VPWR VPWR sky130_fd_sc_hd__fill_1
XANTENNA__4630__B1 _4678_/C1 VGND VGND VPWR VPWR sky130_fd_sc_hd__diode_2
XFILLER_12_121 VPWR VGND VPWR VGND sky130_ef_sc_hd__decap_12
XFILLER_13_677 VGND VGND VPWR VPWR sky130_fd_sc_hd__fill_1
XANTENNA__3197__A0 _2843_/B VGND VGND VPWR VPWR sky130_fd_sc_hd__diode_2
XTAP_TAPCELL_ROW_10_300 VGND VPWR sky130_fd_sc_hd__tapvpwrvgnd_1
XPHY_EDGE_ROW_57_Left_138 VGND VGND VPWR VPWR sky130_fd_sc_hd__decap_3
XTAP_TAPCELL_ROW_10_311 VGND VPWR sky130_fd_sc_hd__tapvpwrvgnd_1
XFILLER_32_50 VGND VGND VPWR VPWR sky130_fd_sc_hd__fill_1
XTAP_TAPCELL_ROW_78_1154 VGND VPWR sky130_fd_sc_hd__tapvpwrvgnd_1
XPHY_EDGE_ROW_66_Left_147 VGND VGND VPWR VPWR sky130_fd_sc_hd__decap_3
XANTENNA__5110__A1 _5447_/A VGND VGND VPWR VPWR sky130_fd_sc_hd__diode_2
XTAP_TAPCELL_ROW_18_400 VGND VPWR sky130_fd_sc_hd__tapvpwrvgnd_1
XANTENNA__4464__A _4464_/A VGND VGND VPWR VPWR sky130_fd_sc_hd__diode_2
XTAP_TAPCELL_ROW_18_411 VGND VPWR sky130_fd_sc_hd__tapvpwrvgnd_1
XFILLER_63_577 VGND VGND VPWR VPWR sky130_fd_sc_hd__fill_1
X_3961_ _3961_/A _3961_/B VGND VGND VPWR VPWR _5613_/D sky130_fd_sc_hd__and2_1
XFILLER_35_279 VGND VGND VPWR VPWR sky130_fd_sc_hd__fill_1
XTAP_TAPCELL_ROW_46_753 VGND VPWR sky130_fd_sc_hd__tapvpwrvgnd_1
X_2912_ _5843_/Q _2917_/A2 _2886_/B _5847_/Q VGND VGND VPWR VPWR _2912_/X sky130_fd_sc_hd__a22o_1
X_5700_ _5788_/CLK _5700_/D fanout297/X VGND VGND VPWR VPWR _5700_/Q sky130_fd_sc_hd__dfrtp_4
XFILLER_31_430 VGND VGND VPWR VPWR sky130_fd_sc_hd__decap_4
X_3892_ _3392_/X _3766_/Y _3891_/X _3906_/A2 VGND VGND VPWR VPWR _4106_/B sky130_fd_sc_hd__a22oi_2
XPHY_EDGE_ROW_75_Left_156 VGND VGND VPWR VPWR sky130_fd_sc_hd__decap_3
X_2843_ _2844_/D _2843_/B _2834_/C _2844_/C VGND VGND VPWR VPWR _2843_/X sky130_fd_sc_hd__or4bb_1
X_5631_ _5690_/CLK hold1/X VGND VGND VPWR VPWR hold5/A sky130_fd_sc_hd__dfxtp_1
XANTENNA__5177__A1 _3651_/B VGND VGND VPWR VPWR sky130_fd_sc_hd__diode_2
X_2774_ _2774_/A _5701_/Q VGND VGND VPWR VPWR _4138_/A sky130_fd_sc_hd__nand2_1
XANTENNA__3808__A _5397_/A VGND VGND VPWR VPWR sky130_fd_sc_hd__diode_2
X_5562_ _5686_/CLK _5562_/D VGND VGND VPWR VPWR hold65/A sky130_fd_sc_hd__dfxtp_1
XFILLER_8_692 VGND VGND VPWR VPWR sky130_fd_sc_hd__decap_8
X_4513_ _4522_/A _5748_/Q _4522_/D _4512_/Y _4527_/S VGND VGND VPWR VPWR _4513_/X
+ sky130_fd_sc_hd__a311o_1
X_5493_ _6021_/CLK _5493_/D fanout332/X VGND VGND VPWR VPWR _5493_/Q sky130_fd_sc_hd__dfrtp_4
Xhold103 _5706_/Q VGND VGND VPWR VPWR hold103/X sky130_fd_sc_hd__dlygate4sd3_1
Xhold125 _5850_/Q VGND VGND VPWR VPWR hold125/X sky130_fd_sc_hd__dlygate4sd3_1
Xhold114 _5660_/Q VGND VGND VPWR VPWR hold114/X sky130_fd_sc_hd__dlygate4sd3_1
Xhold158 _5707_/Q VGND VGND VPWR VPWR hold158/X sky130_fd_sc_hd__dlygate4sd3_1
Xhold136 _5818_/Q VGND VGND VPWR VPWR hold136/X sky130_fd_sc_hd__dlygate4sd3_1
Xclkbuf_leaf_7_clk clkbuf_leaf_9_clk/A VGND VGND VPWR VPWR _6032_/CLK sky130_fd_sc_hd__clkbuf_8
Xhold147 _5816_/Q VGND VGND VPWR VPWR hold147/X sky130_fd_sc_hd__dlygate4sd3_1
X_4444_ _4447_/A _4444_/B _4444_/C VGND VGND VPWR VPWR _4467_/C sky130_fd_sc_hd__or3_2
Xhold169 _6063_/Q VGND VGND VPWR VPWR hold169/X sky130_fd_sc_hd__dlygate4sd3_1
X_4375_ _4829_/C _4452_/B VGND VGND VPWR VPWR _4376_/B sky130_fd_sc_hd__nor2_1
X_6114_ _6163_/CLK _6114_/D fanout314/X VGND VGND VPWR VPWR _6114_/Q sky130_fd_sc_hd__dfrtp_4
X_3326_ _3365_/B _3365_/C _3326_/C _3326_/D VGND VGND VPWR VPWR _3326_/X sky130_fd_sc_hd__or4_1
XFILLER_58_349 VGND VGND VPWR VPWR sky130_fd_sc_hd__fill_1
X_6045_ _6106_/CLK _6045_/D fanout275/X VGND VGND VPWR VPWR _6045_/Q sky130_fd_sc_hd__dfrtp_1
XANTENNA__5101__A1 _5200_/C VGND VGND VPWR VPWR sky130_fd_sc_hd__diode_2
X_3257_ _6126_/Q _6127_/Q _6125_/Q VGND VGND VPWR VPWR _3472_/A sky130_fd_sc_hd__or3b_1
XANTENNA_fanout284_A fanout286/X VGND VGND VPWR VPWR sky130_fd_sc_hd__diode_2
XANTENNA__4860__A0 _2934_/B VGND VGND VPWR VPWR sky130_fd_sc_hd__diode_2
X_3188_ _5466_/Q _4083_/B VGND VGND VPWR VPWR _3189_/B sky130_fd_sc_hd__and2_1
XANTENNA__4374__A _4829_/C VGND VGND VPWR VPWR sky130_fd_sc_hd__diode_2
XFILLER_14_419 VGND VGND VPWR VPWR sky130_fd_sc_hd__fill_1
XANTENNA__4612__B1 _4684_/B1 VGND VGND VPWR VPWR sky130_fd_sc_hd__diode_2
XANTENNA__5168__A1 _5728_/Q VGND VGND VPWR VPWR sky130_fd_sc_hd__diode_2
X_5829_ _6092_/CLK _5829_/D fanout339/X VGND VGND VPWR VPWR _5829_/Q sky130_fd_sc_hd__dfrtp_1
XFILLER_22_474 VGND VGND VPWR VPWR sky130_fd_sc_hd__fill_2
XANTENNA__2926__B1 _2926_/B1 VGND VGND VPWR VPWR sky130_fd_sc_hd__diode_2
XANTENNA__5144__S _5166_/S VGND VGND VPWR VPWR sky130_fd_sc_hd__diode_2
XFILLER_76_124 VPWR VGND VPWR VGND sky130_ef_sc_hd__decap_12
XTAP_TAPCELL_ROW_73_1095 VGND VPWR sky130_fd_sc_hd__tapvpwrvgnd_1
XANTENNA__4851__A0 _5469_/Q VGND VGND VPWR VPWR sky130_fd_sc_hd__diode_2
XFILLER_27_61 VGND VGND VPWR VPWR sky130_fd_sc_hd__fill_1
XFILLER_72_363 VGND VGND VPWR VPWR sky130_fd_sc_hd__fill_1
XFILLER_17_268 VGND VGND VPWR VPWR sky130_fd_sc_hd__decap_3
XFILLER_17_279 VGND VGND VPWR VPWR sky130_fd_sc_hd__fill_1
XANTENNA__3406__A1 _5523_/Q VGND VGND VPWR VPWR sky130_fd_sc_hd__diode_2
XANTENNA__4603__B1 _4667_/B1 VGND VGND VPWR VPWR sky130_fd_sc_hd__diode_2
XFILLER_32_238 VGND VGND VPWR VPWR sky130_fd_sc_hd__decap_4
XTAP_TAPCELL_ROW_43_712 VGND VPWR sky130_fd_sc_hd__tapvpwrvgnd_1
XTAP_TAPCELL_ROW_43_723 VGND VPWR sky130_fd_sc_hd__tapvpwrvgnd_1
XANTENNA__5159__A1 _5469_/Q VGND VGND VPWR VPWR sky130_fd_sc_hd__diode_2
XFILLER_4_161 VPWR VGND VPWR VGND sky130_ef_sc_hd__decap_12
X_4160_ _4155_/A _2774_/A _5701_/Q VGND VGND VPWR VPWR _4160_/X sky130_fd_sc_hd__a21o_1
XFILLER_67_113 VGND VGND VPWR VPWR sky130_fd_sc_hd__decap_4
X_3111_ _3955_/A _3110_/X _3953_/B VGND VGND VPWR VPWR _3111_/X sky130_fd_sc_hd__a21bo_1
X_4091_ _5589_/Q hold66/X _4091_/S VGND VGND VPWR VPWR _5698_/D sky130_fd_sc_hd__mux2_1
XFILLER_67_179 VGND VGND VPWR VPWR sky130_fd_sc_hd__decap_4
X_3042_ _5910_/Q _2987_/Y _3040_/X _3041_/X _2989_/Y VGND VGND VPWR VPWR _3042_/X
+ sky130_fd_sc_hd__o221a_1
XANTENNA__4842__A0 _5488_/Q VGND VGND VPWR VPWR sky130_fd_sc_hd__diode_2
XFILLER_36_511 VPWR VGND VPWR VGND sky130_ef_sc_hd__decap_12
XANTENNA__2999__A3 _2824_/C VGND VGND VPWR VPWR sky130_fd_sc_hd__diode_2
X_4993_ hold448/X _5041_/A2 _4992_/X VGND VGND VPWR VPWR _5942_/D sky130_fd_sc_hd__a21o_1
X_3944_ _5602_/Q _3559_/Y _5353_/A VGND VGND VPWR VPWR _5602_/D sky130_fd_sc_hd__mux2_1
X_3875_ _5577_/Q _3826_/S _3872_/Y _3874_/Y VGND VGND VPWR VPWR _5577_/D sky130_fd_sc_hd__o22a_1
X_2826_ _2844_/D _2834_/C _2844_/C VGND VGND VPWR VPWR _2935_/B sky130_fd_sc_hd__or3b_1
XTAP_TAPCELL_ROW_21_439 VGND VPWR sky130_fd_sc_hd__tapvpwrvgnd_1
X_5614_ _5686_/CLK _5614_/D fanout322/X VGND VGND VPWR VPWR _5614_/Q sky130_fd_sc_hd__dfrtp_1
X_5545_ _5686_/CLK _5545_/D VGND VGND VPWR VPWR hold17/A sky130_fd_sc_hd__dfxtp_1
X_2757_ _6031_/Q VGND VGND VPWR VPWR _3270_/B sky130_fd_sc_hd__inv_2
X_5476_ _5966_/CLK _5476_/D fanout304/X VGND VGND VPWR VPWR _5476_/Q sky130_fd_sc_hd__dfrtp_4
XANTENNA__5939__RESET_B fanout307/X VGND VGND VPWR VPWR sky130_fd_sc_hd__diode_2
X_4427_ _4427_/A _4475_/B VGND VGND VPWR VPWR _4427_/Y sky130_fd_sc_hd__nand2_1
XANTENNA__3273__A _5406_/A VGND VGND VPWR VPWR sky130_fd_sc_hd__diode_2
XANTENNA_input4_A uio_in[3] VGND VGND VPWR VPWR sky130_fd_sc_hd__diode_2
XFILLER_48_49 VGND VGND VPWR VPWR sky130_fd_sc_hd__fill_1
X_4358_ _4355_/X _4357_/X _4351_/Y VGND VGND VPWR VPWR _5736_/D sky130_fd_sc_hd__o21ai_1
X_4289_ _5570_/Q _5578_/Q _4307_/S VGND VGND VPWR VPWR _4289_/X sky130_fd_sc_hd__mux2_1
XANTENNA_fanout287_X fanout287/X VGND VGND VPWR VPWR sky130_fd_sc_hd__diode_2
X_3309_ _5412_/A _5984_/Q VGND VGND VPWR VPWR _3365_/B sky130_fd_sc_hd__and2b_1
XFILLER_58_179 VGND VGND VPWR VPWR sky130_fd_sc_hd__fill_2
XANTENNA__4833__A0 _5517_/Q VGND VGND VPWR VPWR sky130_fd_sc_hd__diode_2
XFILLER_39_360 VGND VGND VPWR VPWR sky130_fd_sc_hd__decap_4
X_6028_ _6050_/CLK _6028_/D fanout290/X VGND VGND VPWR VPWR _6028_/Q sky130_fd_sc_hd__dfrtp_1
XTAP_TAPCELL_ROW_29_539 VGND VPWR sky130_fd_sc_hd__tapvpwrvgnd_1
XFILLER_64_59 VGND VGND VPWR VPWR sky130_fd_sc_hd__decap_8
XANTENNA__3212__S _3219_/S VGND VGND VPWR VPWR sky130_fd_sc_hd__diode_2
XTAP_TAPCELL_ROW_1_197 VGND VPWR sky130_fd_sc_hd__tapvpwrvgnd_1
Xfanout20 _3731_/Y VGND VGND VPWR VPWR _4164_/A sky130_fd_sc_hd__clkbuf_2
Xfanout31 _3726_/X VGND VGND VPWR VPWR _4776_/S sky130_fd_sc_hd__clkbuf_4
Xfanout42 _4747_/B1 VGND VGND VPWR VPWR _4683_/B1 sky130_fd_sc_hd__clkbuf_2
Xfanout53 _4175_/X VGND VGND VPWR VPWR _4678_/A1 sky130_fd_sc_hd__buf_2
Xfanout64 _3880_/B VGND VGND VPWR VPWR _3869_/B sky130_fd_sc_hd__buf_1
Xfanout97 _5170_/S VGND VGND VPWR VPWR _5166_/S sky130_fd_sc_hd__clkbuf_4
Xfanout86 _5442_/B VGND VGND VPWR VPWR _5427_/B sky130_fd_sc_hd__clkbuf_2
Xfanout75 _4870_/A1 VGND VGND VPWR VPWR _4544_/A sky130_fd_sc_hd__buf_2
XANTENNA__5010__B1 _5024_/B1 VGND VGND VPWR VPWR sky130_fd_sc_hd__diode_2
XFILLER_6_404 VGND VGND VPWR VPWR sky130_fd_sc_hd__fill_1
XFILLER_13_96 VGND VGND VPWR VPWR sky130_fd_sc_hd__decap_8
XTAP_TAPCELL_ROW_75_1113 VGND VPWR sky130_fd_sc_hd__tapvpwrvgnd_1
XTAP_TAPCELL_ROW_9_297 VGND VPWR sky130_fd_sc_hd__tapvpwrvgnd_1
XFILLER_18_533 VGND VGND VPWR VPWR sky130_fd_sc_hd__decap_6
XTAP_TAPCELL_ROW_56_881 VGND VPWR sky130_fd_sc_hd__tapvpwrvgnd_1
XFILLER_60_388 VGND VGND VPWR VPWR sky130_fd_sc_hd__fill_1
X_3660_ _3660_/A _3697_/A _3660_/C _3660_/D VGND VGND VPWR VPWR _3661_/D sky130_fd_sc_hd__or4_1
Xclkload23 _5942_/CLK VGND VGND VPWR VPWR clkload23/Y sky130_fd_sc_hd__clkinv_8
Xclkload12 _6106_/CLK VGND VGND VPWR VPWR clkload12/Y sky130_fd_sc_hd__clkinv_4
X_3591_ _3647_/A _6106_/Q VGND VGND VPWR VPWR _3591_/X sky130_fd_sc_hd__and2b_1
Xclkload34 _5685_/CLK VGND VGND VPWR VPWR clkload34/Y sky130_fd_sc_hd__bufinv_16
Xclkload45 _6085_/CLK VGND VGND VPWR VPWR clkload45/Y sky130_fd_sc_hd__clkinvlp_4
XFILLER_55_3 VPWR VGND VPWR VGND sky130_ef_sc_hd__decap_12
X_5330_ _6157_/Q _5337_/B _5325_/X VGND VGND VPWR VPWR _5330_/Y sky130_fd_sc_hd__a21oi_1
X_5261_ _6147_/Q _5285_/B VGND VGND VPWR VPWR _5262_/B sky130_fd_sc_hd__or2_1
XANTENNA_clkbuf_leaf_53_clk_A clkload0/A VGND VGND VPWR VPWR sky130_fd_sc_hd__diode_2
X_4212_ _5789_/Q _4167_/Y _4170_/Y _5781_/Q _4168_/Y VGND VGND VPWR VPWR _4212_/X
+ sky130_fd_sc_hd__a221o_1
XANTENNA__3866__A1 _5201_/B VGND VGND VPWR VPWR sky130_fd_sc_hd__diode_2
X_5192_ _2864_/A _5192_/A2 _4539_/X _5737_/Q VGND VGND VPWR VPWR _6113_/D sky130_fd_sc_hd__a22o_1
X_4143_ _4320_/A _4141_/X _4142_/X _4135_/X _4137_/Y VGND VGND VPWR VPWR _4157_/A
+ sky130_fd_sc_hd__o311a_1
XFILLER_68_477 VGND VGND VPWR VPWR sky130_fd_sc_hd__decap_4
X_4074_ hold26/A hold55/A hold54/A hold66/A _4052_/S _4074_/S1 VGND VGND VPWR VPWR
+ _4074_/X sky130_fd_sc_hd__mux4_1
X_3025_ _5925_/Q _2978_/Y _3023_/X _3024_/X VGND VGND VPWR VPWR _3025_/X sky130_fd_sc_hd__o22a_1
XTAP_TAPCELL_ROW_26_509 VGND VPWR sky130_fd_sc_hd__tapvpwrvgnd_1
XFILLER_12_709 VGND VGND VPWR VPWR sky130_fd_sc_hd__decap_4
XFILLER_11_219 VGND VGND VPWR VPWR sky130_fd_sc_hd__decap_4
X_4976_ _5935_/Q _5189_/A2 _3254_/A _5863_/D VGND VGND VPWR VPWR _5935_/D sky130_fd_sc_hd__a22o_1
X_3927_ _6129_/D _5362_/B _3930_/C _6128_/D VGND VGND VPWR VPWR _3928_/B sky130_fd_sc_hd__or4b_1
Xclkload6 clkload6/A VGND VGND VPWR VPWR clkload6/Y sky130_fd_sc_hd__clkinv_8
X_3858_ _3783_/A _3853_/X _3857_/X VGND VGND VPWR VPWR _4102_/C sky130_fd_sc_hd__a21oi_1
X_2809_ _6114_/Q _6115_/Q VGND VGND VPWR VPWR _2809_/Y sky130_fd_sc_hd__nor2_1
X_3789_ _5570_/Q _3826_/S _3787_/X _3788_/Y VGND VGND VPWR VPWR _5570_/D sky130_fd_sc_hd__o22a_1
X_5528_ _6149_/CLK _5528_/D VGND VGND VPWR VPWR hold18/A sky130_fd_sc_hd__dfxtp_1
XFILLER_3_407 VGND VGND VPWR VPWR sky130_fd_sc_hd__fill_1
X_5459_ _6177_/Q _5459_/B VGND VGND VPWR VPWR _5459_/Y sky130_fd_sc_hd__nor2_1
Xfanout221 _5756_/Q VGND VGND VPWR VPWR _2842_/B sky130_fd_sc_hd__dlymetal6s2s_1
Xfanout232 _4522_/C VGND VGND VPWR VPWR _4517_/A sky130_fd_sc_hd__clkbuf_4
Xfanout210 _2977_/A VGND VGND VPWR VPWR _4166_/B sky130_fd_sc_hd__buf_1
XTAP_TAPCELL_ROW_70_1054 VGND VPWR sky130_fd_sc_hd__tapvpwrvgnd_1
XTAP_TAPCELL_ROW_6_256 VGND VPWR sky130_fd_sc_hd__tapvpwrvgnd_1
Xfanout265 _5610_/Q VGND VGND VPWR VPWR _3955_/A sky130_fd_sc_hd__clkbuf_4
Xfanout243 _5744_/Q VGND VGND VPWR VPWR _2744_/A sky130_fd_sc_hd__buf_2
Xfanout254 _4829_/C VGND VGND VPWR VPWR _4873_/A sky130_fd_sc_hd__buf_2
Xfanout298 fanout309/X VGND VGND VPWR VPWR fanout298/X sky130_fd_sc_hd__clkbuf_2
Xfanout276 fanout287/X VGND VGND VPWR VPWR fanout276/X sky130_fd_sc_hd__clkbuf_2
Xfanout287 input1/X VGND VGND VPWR VPWR fanout287/X sky130_fd_sc_hd__clkbuf_4
XANTENNA__4806__A0 _2934_/B VGND VGND VPWR VPWR sky130_fd_sc_hd__diode_2
XANTENNA_fanout62_A _3905_/B VGND VGND VPWR VPWR sky130_fd_sc_hd__diode_2
XANTENNA__4038__S _4052_/S VGND VGND VPWR VPWR sky130_fd_sc_hd__diode_2
XANTENNA__2832__A2 _5487_/Q VGND VGND VPWR VPWR sky130_fd_sc_hd__diode_2
XFILLER_15_514 VGND VGND VPWR VPWR sky130_fd_sc_hd__fill_1
XANTENNA__3877__S _3877_/S VGND VGND VPWR VPWR sky130_fd_sc_hd__diode_2
XTAP_TAPCELL_ROW_53_840 VGND VPWR sky130_fd_sc_hd__tapvpwrvgnd_1
XFILLER_6_223 VGND VGND VPWR VPWR sky130_fd_sc_hd__decap_8
XANTENNA__4742__C1 _4750_/C1 VGND VGND VPWR VPWR sky130_fd_sc_hd__diode_2
XANTENNA__5393__A _6167_/Q VGND VGND VPWR VPWR sky130_fd_sc_hd__diode_2
XFILLER_40_83 VGND VGND VPWR VPWR sky130_fd_sc_hd__fill_1
XFILLER_65_447 VGND VGND VPWR VPWR sky130_fd_sc_hd__fill_1
XFILLER_1_55 VGND VGND VPWR VPWR sky130_fd_sc_hd__fill_1
XFILLER_46_661 VGND VGND VPWR VPWR sky130_fd_sc_hd__fill_1
XFILLER_18_363 VGND VGND VPWR VPWR sky130_fd_sc_hd__fill_1
X_4830_ _4830_/A _5138_/S VGND VGND VPWR VPWR _5865_/D sky130_fd_sc_hd__or2_1
X_4761_ _5800_/Q _4761_/A2 _4828_/B2 _3564_/A VGND VGND VPWR VPWR _5800_/D sky130_fd_sc_hd__a22o_1
X_4692_ _5960_/Q _4748_/A2 _4243_/S _4691_/X VGND VGND VPWR VPWR _4692_/X sky130_fd_sc_hd__a211o_1
X_3712_ _3712_/A _3712_/B _5865_/Q VGND VGND VPWR VPWR _3717_/B sky130_fd_sc_hd__or3b_1
XTAP_TAPCELL_ROW_31_567 VGND VPWR sky130_fd_sc_hd__tapvpwrvgnd_1
X_3643_ _6038_/Q _4444_/B VGND VGND VPWR VPWR _3694_/A sky130_fd_sc_hd__and2b_1
XANTENNA__2720__A _5719_/Q VGND VGND VPWR VPWR sky130_fd_sc_hd__diode_2
X_3574_ _6103_/Q _3623_/A VGND VGND VPWR VPWR _3574_/X sky130_fd_sc_hd__or2_1
X_5313_ _5301_/A _5301_/B _5301_/C _5307_/B VGND VGND VPWR VPWR _5315_/B sky130_fd_sc_hd__a211oi_1
X_5244_ _5244_/A _5244_/B _5244_/C VGND VGND VPWR VPWR _5244_/Y sky130_fd_sc_hd__nor3_1
Xhold29 hold29/A VGND VGND VPWR VPWR hold29/X sky130_fd_sc_hd__dlygate4sd3_1
Xhold18 hold18/A VGND VGND VPWR VPWR hold18/X sky130_fd_sc_hd__dlygate4sd3_1
X_5175_ hold170/X _5189_/A2 _4166_/C VGND VGND VPWR VPWR _6097_/D sky130_fd_sc_hd__a21o_1
X_4126_ _4126_/A _4126_/B _4126_/C _4126_/D VGND VGND VPWR VPWR _4148_/B sky130_fd_sc_hd__or4_1
XTAP_TAPCELL_ROW_3_215 VGND VPWR sky130_fd_sc_hd__tapvpwrvgnd_1
X_4057_ _3967_/A _4057_/B VGND VGND VPWR VPWR _4057_/X sky130_fd_sc_hd__and2b_1
XTAP_TAPCELL_ROW_39_667 VGND VPWR sky130_fd_sc_hd__tapvpwrvgnd_1
X_3008_ _3006_/X _3007_/X _3953_/B VGND VGND VPWR VPWR _3008_/X sky130_fd_sc_hd__mux2_1
XFILLER_64_491 VGND VGND VPWR VPWR sky130_fd_sc_hd__fill_1
XTAP_TAPCELL_ROW_50_810 VGND VPWR sky130_fd_sc_hd__tapvpwrvgnd_1
X_4959_ _4711_/X _4878_/A _4878_/B _4958_/X VGND VGND VPWR VPWR _4959_/X sky130_fd_sc_hd__a22o_1
XANTENNA__5628__D hold10/X VGND VGND VPWR VPWR sky130_fd_sc_hd__diode_2
XFILLER_75_712 VGND VGND VPWR VPWR sky130_fd_sc_hd__fill_1
XANTENNA__5152__S _5172_/S VGND VGND VPWR VPWR sky130_fd_sc_hd__diode_2
XTAP_TAPCELL_ROW_58_910 VGND VPWR sky130_fd_sc_hd__tapvpwrvgnd_1
XFILLER_47_469 VGND VGND VPWR VPWR sky130_fd_sc_hd__decap_4
XANTENNA__2805__A2 _2910_/B VGND VGND VPWR VPWR sky130_fd_sc_hd__diode_2
XANTENNA__3400__S _3407_/S VGND VGND VPWR VPWR sky130_fd_sc_hd__diode_2
XFILLER_7_554 VGND VGND VPWR VPWR sky130_fd_sc_hd__fill_2
X_3290_ _3298_/A _6029_/Q VGND VGND VPWR VPWR _3333_/B sky130_fd_sc_hd__nor2_1
XANTENNA__5062__S _5066_/S VGND VGND VPWR VPWR sky130_fd_sc_hd__diode_2
XFILLER_18_3 VPWR VGND VPWR VGND sky130_ef_sc_hd__decap_12
XFILLER_80_225 VGND VGND VPWR VPWR sky130_fd_sc_hd__fill_1
X_5931_ _5942_/CLK _5931_/D fanout304/X VGND VGND VPWR VPWR _5931_/Q sky130_fd_sc_hd__dfrtp_1
XFILLER_65_277 VGND VGND VPWR VPWR sky130_fd_sc_hd__fill_1
XTAP_TAPCELL_ROW_36_626 VGND VPWR sky130_fd_sc_hd__tapvpwrvgnd_1
XFILLER_18_193 VGND VGND VPWR VPWR sky130_fd_sc_hd__decap_3
XTAP_TAPCELL_ROW_64_979 VGND VPWR sky130_fd_sc_hd__tapvpwrvgnd_1
X_5862_ _6032_/CLK _5862_/D fanout299/X VGND VGND VPWR VPWR _5862_/Q sky130_fd_sc_hd__dfrtp_1
XTAP_TAPCELL_ROW_16_383 VGND VPWR sky130_fd_sc_hd__tapvpwrvgnd_1
XFILLER_21_314 VGND VGND VPWR VPWR sky130_fd_sc_hd__fill_1
X_4813_ _4813_/A1 _4824_/A2 _4824_/B1 hold100/X VGND VGND VPWR VPWR _5849_/D sky130_fd_sc_hd__a22o_1
XFILLER_33_185 VGND VGND VPWR VPWR sky130_fd_sc_hd__decap_6
X_5793_ _6111_/CLK _5793_/D fanout313/X VGND VGND VPWR VPWR _5793_/Q sky130_fd_sc_hd__dfrtp_2
X_4744_ _4235_/S _4743_/X _4742_/X _3877_/S VGND VGND VPWR VPWR _4744_/X sky130_fd_sc_hd__a211o_1
X_4675_ _5925_/Q _4747_/A2 _4683_/B1 _4674_/X VGND VGND VPWR VPWR _4675_/X sky130_fd_sc_hd__a22o_1
X_3626_ _3626_/A _5974_/Q VGND VGND VPWR VPWR _3633_/C sky130_fd_sc_hd__xor2_1
X_3557_ _3516_/X _3523_/Y _3522_/X VGND VGND VPWR VPWR _3557_/Y sky130_fd_sc_hd__a21oi_2
X_5227_ _3487_/B _5211_/B _5226_/X _3491_/A VGND VGND VPWR VPWR _5228_/B sky130_fd_sc_hd__a211o_1
X_3488_ _4350_/A _3488_/B VGND VGND VPWR VPWR _3492_/B sky130_fd_sc_hd__nor2_1
XFILLER_69_561 VGND VGND VPWR VPWR sky130_fd_sc_hd__fill_1
XFILLER_56_27 VGND VGND VPWR VPWR sky130_fd_sc_hd__fill_1
X_5158_ hold286/X _5468_/Q _5166_/S VGND VGND VPWR VPWR _6080_/D sky130_fd_sc_hd__mux2_1
X_5089_ hold212/X _5472_/Q _5096_/S VGND VGND VPWR VPWR _6012_/D sky130_fd_sc_hd__mux2_1
X_4109_ _4866_/S _5566_/Q _4109_/C _4865_/A VGND VGND VPWR VPWR _4109_/Y sky130_fd_sc_hd__nand4_1
XFILLER_72_15 VGND VGND VPWR VPWR sky130_fd_sc_hd__decap_8
XFILLER_72_26 VGND VGND VPWR VPWR sky130_fd_sc_hd__fill_2
XFILLER_40_645 VGND VGND VPWR VPWR sky130_fd_sc_hd__fill_2
XFILLER_8_307 VGND VGND VPWR VPWR sky130_fd_sc_hd__fill_1
XANTENNA__5147__S _5167_/S VGND VGND VPWR VPWR sky130_fd_sc_hd__diode_2
XANTENNA__3920__B1 _3554_/Y VGND VGND VPWR VPWR sky130_fd_sc_hd__diode_2
XFILLER_48_712 VGND VGND VPWR VPWR sky130_fd_sc_hd__fill_1
XFILLER_47_255 VGND VGND VPWR VPWR sky130_fd_sc_hd__fill_1
XANTENNA__4226__S _4226_/S VGND VGND VPWR VPWR sky130_fd_sc_hd__diode_2
XTAP_TAPCELL_ROW_61_938 VGND VPWR sky130_fd_sc_hd__tapvpwrvgnd_1
XFILLER_30_111 VGND VGND VPWR VPWR sky130_fd_sc_hd__fill_1
XFILLER_43_483 VGND VGND VPWR VPWR sky130_fd_sc_hd__fill_1
XTAP_TAPCELL_ROW_13_342 VGND VPWR sky130_fd_sc_hd__tapvpwrvgnd_1
XANTENNA__3918__X _3918_/X VGND VGND VPWR VPWR sky130_fd_sc_hd__diode_2
X_2790_ _2925_/D _2920_/B _2925_/B _6019_/Q VGND VGND VPWR VPWR _2790_/X sky130_fd_sc_hd__and4_1
XFILLER_30_188 VGND VGND VPWR VPWR sky130_fd_sc_hd__decap_8
XANTENNA__4951__A2 _4951_/A2 VGND VGND VPWR VPWR sky130_fd_sc_hd__diode_2
XANTENNA__5057__S _5066_/S VGND VGND VPWR VPWR sky130_fd_sc_hd__diode_2
XTAP_TAPCELL_ROW_41_695 VGND VPWR sky130_fd_sc_hd__tapvpwrvgnd_1
Xhold307 _6044_/Q VGND VGND VPWR VPWR hold307/X sky130_fd_sc_hd__dlygate4sd3_1
X_4460_ _4467_/A _4460_/B VGND VGND VPWR VPWR _4460_/Y sky130_fd_sc_hd__nor2_1
Xhold329 _6060_/Q VGND VGND VPWR VPWR hold329/X sky130_fd_sc_hd__dlygate4sd3_1
X_3411_ hold61/X _5637_/Q _3416_/S VGND VGND VPWR VPWR _5527_/D sky130_fd_sc_hd__mux2_1
Xhold318 _6038_/Q VGND VGND VPWR VPWR hold318/X sky130_fd_sc_hd__dlygate4sd3_1
X_4391_ _4378_/A _4378_/B _4376_/A VGND VGND VPWR VPWR _4392_/B sky130_fd_sc_hd__a21o_1
X_6130_ _6131_/CLK _6130_/D fanout328/X VGND VGND VPWR VPWR _6130_/Q sky130_fd_sc_hd__dfstp_1
X_3342_ _5200_/C _3305_/B _3298_/A _5985_/Q VGND VGND VPWR VPWR _3361_/C sky130_fd_sc_hd__a22o_1
X_6061_ _6061_/CLK _6061_/D fanout283/X VGND VGND VPWR VPWR _6061_/Q sky130_fd_sc_hd__dfrtp_1
X_3273_ _5406_/A _6027_/Q VGND VGND VPWR VPWR _3357_/A sky130_fd_sc_hd__xor2_1
X_5012_ _4629_/X _5026_/A2 _5026_/B1 _4928_/X VGND VGND VPWR VPWR _5012_/X sky130_fd_sc_hd__a22o_1
XFILLER_66_564 VGND VGND VPWR VPWR sky130_fd_sc_hd__fill_1
XFILLER_53_247 VGND VGND VPWR VPWR sky130_fd_sc_hd__fill_1
XFILLER_53_225 VGND VGND VPWR VPWR sky130_fd_sc_hd__fill_1
XTAP_TAPCELL_ROW_49_795 VGND VPWR sky130_fd_sc_hd__tapvpwrvgnd_1
X_5914_ _5952_/CLK _5914_/D fanout330/X VGND VGND VPWR VPWR _5914_/Q sky130_fd_sc_hd__dfrtp_1
X_5845_ _6092_/CLK _5845_/D fanout336/X VGND VGND VPWR VPWR _5845_/Q sky130_fd_sc_hd__dfrtp_1
XFILLER_22_645 VPWR VGND VPWR VGND sky130_ef_sc_hd__decap_12
XFILLER_42_29 VGND VGND VPWR VPWR sky130_fd_sc_hd__decap_4
X_2988_ _5911_/Q _2988_/B VGND VGND VPWR VPWR _2988_/Y sky130_fd_sc_hd__nand2_1
X_5776_ _5942_/CLK _5776_/D fanout296/X VGND VGND VPWR VPWR _5776_/Q sky130_fd_sc_hd__dfrtp_1
X_4727_ _5764_/Q _5931_/Q _4751_/S VGND VGND VPWR VPWR _4727_/X sky130_fd_sc_hd__mux2_1
X_4658_ _5471_/Q _5797_/Q _4682_/S VGND VGND VPWR VPWR _4658_/X sky130_fd_sc_hd__mux2_1
X_3609_ _6059_/Q _3647_/A VGND VGND VPWR VPWR _3714_/C sky130_fd_sc_hd__and2b_1
X_4589_ _5947_/Q _5763_/Q _4615_/S VGND VGND VPWR VPWR _4589_/X sky130_fd_sc_hd__mux2_1
XANTENNA__3426__D _3426_/D VGND VGND VPWR VPWR sky130_fd_sc_hd__diode_2
XANTENNA__3215__S _3219_/S VGND VGND VPWR VPWR sky130_fd_sc_hd__diode_2
XFILLER_29_233 VGND VGND VPWR VPWR sky130_fd_sc_hd__fill_1
XTAP_TAPCELL_ROW_67_1015 VGND VPWR sky130_fd_sc_hd__tapvpwrvgnd_1
XFILLER_25_461 VPWR VGND VPWR VGND sky130_ef_sc_hd__decap_12
XANTENNA__3969__B1 _4542_/A VGND VGND VPWR VPWR sky130_fd_sc_hd__diode_2
XANTENNA__4046__S _4052_/S VGND VGND VPWR VPWR sky130_fd_sc_hd__diode_2
XANTENNA__4630__A1 _4686_/A1 VGND VGND VPWR VPWR sky130_fd_sc_hd__diode_2
XPHY_EDGE_ROW_11_Right_11 VGND VGND VPWR VPWR sky130_fd_sc_hd__decap_3
XANTENNA_fanout28_X _4672_/A1 VGND VGND VPWR VPWR sky130_fd_sc_hd__diode_2
XFILLER_12_133 VGND VGND VPWR VPWR sky130_fd_sc_hd__decap_6
XANTENNA__3197__A1 _5468_/Q VGND VGND VPWR VPWR sky130_fd_sc_hd__diode_2
XFILLER_12_177 VGND VGND VPWR VPWR sky130_fd_sc_hd__decap_8
XANTENNA__4933__A2 _4951_/A2 VGND VGND VPWR VPWR sky130_fd_sc_hd__diode_2
XTAP_TAPCELL_ROW_10_301 VGND VPWR sky130_fd_sc_hd__tapvpwrvgnd_1
XTAP_TAPCELL_ROW_78_1155 VGND VPWR sky130_fd_sc_hd__tapvpwrvgnd_1
XFILLER_4_321 VGND VGND VPWR VPWR sky130_fd_sc_hd__decap_8
XFILLER_4_365 VGND VGND VPWR VPWR sky130_fd_sc_hd__decap_8
XPHY_EDGE_ROW_20_Right_20 VGND VGND VPWR VPWR sky130_fd_sc_hd__decap_3
XTAP_TAPCELL_ROW_18_401 VGND VPWR sky130_fd_sc_hd__tapvpwrvgnd_1
XANTENNA__2880__B1 _2926_/B1 VGND VGND VPWR VPWR sky130_fd_sc_hd__diode_2
XFILLER_35_225 VPWR VGND VPWR VGND sky130_ef_sc_hd__decap_12
X_3960_ _5613_/Q _3960_/B VGND VGND VPWR VPWR _3961_/B sky130_fd_sc_hd__or2_1
XTAP_TAPCELL_ROW_46_754 VGND VPWR sky130_fd_sc_hd__tapvpwrvgnd_1
X_2911_ _2895_/A _5835_/Q _2783_/B _2921_/B1 _5823_/Q VGND VGND VPWR VPWR _2911_/X
+ sky130_fd_sc_hd__a32o_1
XANTENNA__4621__A1 _5767_/Q VGND VGND VPWR VPWR sky130_fd_sc_hd__diode_2
X_3891_ _5813_/Q _3904_/S _3890_/X _3906_/A1 VGND VGND VPWR VPWR _3891_/X sky130_fd_sc_hd__o211a_1
X_2842_ _4967_/A0 _2842_/B _2844_/D _2844_/C VGND VGND VPWR VPWR _2842_/Y sky130_fd_sc_hd__nand4b_1
X_5630_ _5645_/CLK hold4/X VGND VGND VPWR VPWR hold1/A sky130_fd_sc_hd__dfxtp_1
X_2773_ _2776_/A _5699_/Q VGND VGND VPWR VPWR _4320_/B sky130_fd_sc_hd__nand2_1
XANTENNA__4924__A2 _4951_/A2 VGND VGND VPWR VPWR sky130_fd_sc_hd__diode_2
X_5561_ _5696_/CLK _5561_/D VGND VGND VPWR VPWR hold35/A sky130_fd_sc_hd__dfxtp_1
X_5492_ _6131_/CLK _5492_/D fanout329/X VGND VGND VPWR VPWR _5492_/Q sky130_fd_sc_hd__dfrtp_4
XFILLER_8_671 VGND VGND VPWR VPWR sky130_fd_sc_hd__fill_1
X_4512_ _4522_/A _4522_/D _5748_/Q VGND VGND VPWR VPWR _4512_/Y sky130_fd_sc_hd__a21oi_1
Xhold115 _6019_/Q VGND VGND VPWR VPWR hold115/X sky130_fd_sc_hd__dlygate4sd3_1
Xhold104 _5852_/Q VGND VGND VPWR VPWR hold104/X sky130_fd_sc_hd__dlygate4sd3_1
Xhold126 _5851_/Q VGND VGND VPWR VPWR hold126/X sky130_fd_sc_hd__dlygate4sd3_1
X_4443_ _4496_/A _4443_/B VGND VGND VPWR VPWR _4443_/Y sky130_fd_sc_hd__nor2_1
Xhold148 _6120_/Q VGND VGND VPWR VPWR hold148/X sky130_fd_sc_hd__dlygate4sd3_1
Xhold159 _5809_/Q VGND VGND VPWR VPWR hold159/X sky130_fd_sc_hd__dlygate4sd3_1
Xhold137 _5664_/Q VGND VGND VPWR VPWR hold137/X sky130_fd_sc_hd__dlygate4sd3_1
X_4374_ _4829_/C _4439_/B VGND VGND VPWR VPWR _4376_/A sky130_fd_sc_hd__and2_1
X_3325_ _3325_/A _3360_/C _3365_/D _3325_/D VGND VGND VPWR VPWR _3326_/D sky130_fd_sc_hd__or4_1
X_6113_ _6113_/CLK _6113_/D fanout335/X VGND VGND VPWR VPWR _6113_/Q sky130_fd_sc_hd__dfrtp_2
X_6044_ _6106_/CLK _6044_/D fanout274/X VGND VGND VPWR VPWR _6044_/Q sky130_fd_sc_hd__dfrtp_1
X_3256_ _5217_/A _3454_/D VGND VGND VPWR VPWR _3256_/X sky130_fd_sc_hd__or2_1
XFILLER_66_372 VPWR VGND VPWR VGND sky130_ef_sc_hd__decap_12
X_3187_ _5466_/Q _4083_/B VGND VGND VPWR VPWR _3442_/S sky130_fd_sc_hd__nor2_4
XPHY_EDGE_ROW_14_Left_95 VGND VGND VPWR VPWR sky130_fd_sc_hd__decap_3
X_5828_ _6093_/CLK _5828_/D fanout342/X VGND VGND VPWR VPWR _5828_/Q sky130_fd_sc_hd__dfrtp_1
XANTENNA_fanout232_X _4517_/A VGND VGND VPWR VPWR sky130_fd_sc_hd__diode_2
X_5759_ _6111_/CLK _5759_/D fanout328/X VGND VGND VPWR VPWR _5759_/Q sky130_fd_sc_hd__dfrtp_1
XANTENNA__4679__A1 _5766_/Q VGND VGND VPWR VPWR sky130_fd_sc_hd__diode_2
XTAP_TAPCELL_ROW_73_1096 VGND VPWR sky130_fd_sc_hd__tapvpwrvgnd_1
XFILLER_76_136 VGND VGND VPWR VPWR sky130_fd_sc_hd__fill_1
XANTENNA__5160__S _5172_/S VGND VGND VPWR VPWR sky130_fd_sc_hd__diode_2
XFILLER_45_512 VGND VGND VPWR VPWR sky130_fd_sc_hd__decap_3
XFILLER_72_320 VGND VGND VPWR VPWR sky130_fd_sc_hd__fill_1
XFILLER_17_225 VPWR VGND VPWR VGND sky130_ef_sc_hd__decap_12
XFILLER_45_534 VGND VGND VPWR VPWR sky130_fd_sc_hd__decap_3
XTAP_TAPCELL_ROW_43_713 VGND VPWR sky130_fd_sc_hd__tapvpwrvgnd_1
XANTENNA__4906__A2 _4951_/A2 VGND VGND VPWR VPWR sky130_fd_sc_hd__diode_2
XTAP_TAPCELL_ROW_23_470 VGND VPWR sky130_fd_sc_hd__tapvpwrvgnd_1
XANTENNA__3187__Y _3442_/S VGND VGND VPWR VPWR sky130_fd_sc_hd__diode_2
XFILLER_40_272 VPWR VGND VPWR VGND sky130_ef_sc_hd__decap_12
XFILLER_57_7 VGND VGND VPWR VPWR sky130_fd_sc_hd__fill_1
XANTENNA__3644__A _4399_/A VGND VGND VPWR VPWR sky130_fd_sc_hd__diode_2
XFILLER_4_173 VPWR VGND VPWR VGND sky130_ef_sc_hd__decap_12
XANTENNA__3342__A1 _5200_/C VGND VGND VPWR VPWR sky130_fd_sc_hd__diode_2
XFILLER_67_103 VGND VGND VPWR VPWR sky130_fd_sc_hd__fill_1
X_3110_ hold57/A hold70/A _5609_/Q VGND VGND VPWR VPWR _3110_/X sky130_fd_sc_hd__mux2_1
XANTENNA__5095__A1 _5728_/Q VGND VGND VPWR VPWR sky130_fd_sc_hd__diode_2
XFILLER_67_147 VGND VGND VPWR VPWR sky130_fd_sc_hd__fill_1
X_4090_ _5588_/Q hold62/X _4091_/S VGND VGND VPWR VPWR _5697_/D sky130_fd_sc_hd__mux2_1
X_3041_ _5918_/Q _2988_/B _3127_/B VGND VGND VPWR VPWR _3041_/X sky130_fd_sc_hd__a21o_1
XANTENNA__5070__S _5097_/S VGND VGND VPWR VPWR sky130_fd_sc_hd__diode_2
X_4992_ _4229_/X _4979_/A _4979_/B _4898_/X VGND VGND VPWR VPWR _4992_/X sky130_fd_sc_hd__a22o_1
XFILLER_36_589 VGND VGND VPWR VPWR sky130_fd_sc_hd__decap_3
XFILLER_51_559 VGND VGND VPWR VPWR sky130_fd_sc_hd__fill_1
XFILLER_51_548 VGND VGND VPWR VPWR sky130_fd_sc_hd__fill_1
XFILLER_16_280 VGND VGND VPWR VPWR sky130_fd_sc_hd__fill_2
X_3943_ _5601_/Q _3554_/Y _5353_/A VGND VGND VPWR VPWR _5601_/D sky130_fd_sc_hd__mux2_1
XANTENNA__2723__A _6114_/Q VGND VGND VPWR VPWR sky130_fd_sc_hd__diode_2
X_3874_ _3895_/C _3873_/Y _3917_/S VGND VGND VPWR VPWR _3874_/Y sky130_fd_sc_hd__o21ai_1
X_2825_ _2844_/D _2834_/C _2844_/C VGND VGND VPWR VPWR _2825_/Y sky130_fd_sc_hd__nor3b_1
X_5613_ _5645_/CLK _5613_/D fanout318/X VGND VGND VPWR VPWR _5613_/Q sky130_fd_sc_hd__dfrtp_2
X_5544_ _5697_/CLK _5544_/D VGND VGND VPWR VPWR hold85/A sky130_fd_sc_hd__dfxtp_1
X_2756_ _6028_/Q VGND VGND VPWR VPWR _3272_/B sky130_fd_sc_hd__inv_2
X_5475_ _5788_/CLK _5475_/D fanout304/X VGND VGND VPWR VPWR _5475_/Q sky130_fd_sc_hd__dfrtp_4
X_4426_ _4357_/X _4425_/X _4412_/Y VGND VGND VPWR VPWR _5741_/D sky130_fd_sc_hd__o21ai_1
X_4357_ _5353_/B _4357_/B VGND VGND VPWR VPWR _4357_/X sky130_fd_sc_hd__or2_4
XANTENNA__5086__A1 _5469_/Q VGND VGND VPWR VPWR sky130_fd_sc_hd__diode_2
X_4288_ hold421/X _4287_/X _4312_/S VGND VGND VPWR VPWR _5713_/D sky130_fd_sc_hd__mux2_1
XFILLER_58_147 VPWR VGND VPWR VGND sky130_ef_sc_hd__decap_12
X_3308_ _3362_/B _3364_/B _3364_/C _3365_/A VGND VGND VPWR VPWR _3308_/X sky130_fd_sc_hd__or4_1
X_3239_ _3240_/A _3240_/B VGND VGND VPWR VPWR _3239_/Y sky130_fd_sc_hd__nor2_1
X_6027_ clkload5/A _6027_/D fanout281/X VGND VGND VPWR VPWR _6027_/Q sky130_fd_sc_hd__dfrtp_1
XANTENNA__3929__D_N _6128_/D VGND VGND VPWR VPWR sky130_fd_sc_hd__diode_2
XFILLER_54_342 VGND VGND VPWR VPWR sky130_fd_sc_hd__fill_1
XFILLER_27_556 VGND VGND VPWR VPWR sky130_fd_sc_hd__fill_1
XTAP_TAPCELL_ROW_1_187 VGND VPWR sky130_fd_sc_hd__tapvpwrvgnd_1
XTAP_TAPCELL_ROW_1_198 VGND VPWR sky130_fd_sc_hd__tapvpwrvgnd_1
Xfanout21 _4331_/A1 VGND VGND VPWR VPWR _3916_/S sky130_fd_sc_hd__buf_2
Xfanout10 _4811_/X VGND VGND VPWR VPWR _4824_/B1 sky130_fd_sc_hd__buf_2
XFILLER_80_15 VPWR VGND VPWR VGND sky130_ef_sc_hd__decap_12
Xfanout43 _4561_/Y VGND VGND VPWR VPWR _4747_/B1 sky130_fd_sc_hd__clkbuf_4
Xfanout54 _4686_/B1 VGND VGND VPWR VPWR _4750_/C1 sky130_fd_sc_hd__clkbuf_4
XFILLER_22_250 VGND VGND VPWR VPWR sky130_fd_sc_hd__fill_2
Xfanout32 _3726_/X VGND VGND VPWR VPWR _4774_/S sky130_fd_sc_hd__clkbuf_2
Xfanout65 _3368_/X VGND VGND VPWR VPWR _3880_/B sky130_fd_sc_hd__clkbuf_2
Xfanout98 _5172_/S VGND VGND VPWR VPWR _5167_/S sky130_fd_sc_hd__clkbuf_4
XANTENNA__2871__A_N _2864_/A VGND VGND VPWR VPWR sky130_fd_sc_hd__diode_2
XFILLER_10_434 VPWR VGND VPWR VGND sky130_ef_sc_hd__decap_12
Xfanout87 _5376_/B VGND VGND VPWR VPWR _5442_/B sky130_fd_sc_hd__clkbuf_2
Xfanout76 _4870_/A1 VGND VGND VPWR VPWR _3725_/B sky130_fd_sc_hd__clkbuf_2
XTAP_TAPCELL_ROW_75_1114 VGND VPWR sky130_fd_sc_hd__tapvpwrvgnd_1
XANTENNA__5155__S _5167_/S VGND VGND VPWR VPWR sky130_fd_sc_hd__diode_2
XTAP_TAPCELL_ROW_9_298 VGND VPWR sky130_fd_sc_hd__tapvpwrvgnd_1
XTAP_TAPCELL_ROW_9_287 VGND VPWR sky130_fd_sc_hd__tapvpwrvgnd_1
XFILLER_2_699 VGND VGND VPWR VPWR sky130_fd_sc_hd__fill_1
XFILLER_77_434 VGND VGND VPWR VPWR sky130_fd_sc_hd__fill_1
XANTENNA__5077__A1 _5488_/Q VGND VGND VPWR VPWR sky130_fd_sc_hd__diode_2
XFILLER_64_139 VGND VGND VPWR VPWR sky130_fd_sc_hd__fill_1
XANTENNA__3403__S _3407_/S VGND VGND VPWR VPWR sky130_fd_sc_hd__diode_2
XFILLER_45_342 VGND VGND VPWR VPWR sky130_fd_sc_hd__decap_8
XFILLER_60_301 VGND VGND VPWR VPWR sky130_fd_sc_hd__fill_1
XTAP_TAPCELL_ROW_56_882 VGND VPWR sky130_fd_sc_hd__tapvpwrvgnd_1
XFILLER_18_589 VGND VGND VPWR VPWR sky130_fd_sc_hd__fill_1
XANTENNA__4588__B1 _4684_/A2 VGND VGND VPWR VPWR sky130_fd_sc_hd__diode_2
XANTENNA__3639__A _3639_/A VGND VGND VPWR VPWR sky130_fd_sc_hd__diode_2
XFILLER_13_250 VGND VGND VPWR VPWR sky130_fd_sc_hd__fill_2
XFILLER_13_261 VGND VGND VPWR VPWR sky130_fd_sc_hd__decap_3
XFILLER_13_272 VGND VGND VPWR VPWR sky130_fd_sc_hd__decap_8
XANTENNA__5627__Q hold10/A VGND VGND VPWR VPWR sky130_fd_sc_hd__diode_2
Xclkload24 _5963_/CLK VGND VGND VPWR VPWR clkload24/Y sky130_fd_sc_hd__inv_12
X_3590_ _6098_/Q _4399_/A VGND VGND VPWR VPWR _3710_/A sky130_fd_sc_hd__and2_1
Xclkload35 _5690_/CLK VGND VGND VPWR VPWR clkload35/X sky130_fd_sc_hd__clkbuf_4
Xclkload13 _6107_/CLK VGND VGND VPWR VPWR clkload13/Y sky130_fd_sc_hd__inv_8
Xclkload46 _6093_/CLK VGND VGND VPWR VPWR clkload46/Y sky130_fd_sc_hd__clkinvlp_4
XANTENNA__5065__S _5123_/B VGND VGND VPWR VPWR sky130_fd_sc_hd__diode_2
X_5260_ _6147_/Q _5285_/B VGND VGND VPWR VPWR _5260_/X sky130_fd_sc_hd__and2_1
X_4211_ _5940_/Q _5764_/Q _4232_/S VGND VGND VPWR VPWR _4211_/X sky130_fd_sc_hd__mux2_1
XFILLER_48_3 VPWR VGND VPWR VGND sky130_ef_sc_hd__decap_12
XANTENNA__3866__A2 _4175_/D VGND VGND VPWR VPWR sky130_fd_sc_hd__diode_2
X_5191_ _2871_/C _5192_/A2 _4539_/X _5736_/Q VGND VGND VPWR VPWR _6112_/D sky130_fd_sc_hd__a22o_1
X_4142_ _2774_/A _4158_/B _4247_/A VGND VGND VPWR VPWR _4142_/X sky130_fd_sc_hd__a21o_1
XANTENNA__5068__A1 _5517_/Q VGND VGND VPWR VPWR sky130_fd_sc_hd__diode_2
XFILLER_55_106 VGND VGND VPWR VPWR sky130_fd_sc_hd__decap_6
XFILLER_28_309 VGND VGND VPWR VPWR sky130_fd_sc_hd__decap_4
X_4073_ hold84/X _3975_/Y _4071_/X _4072_/X VGND VGND VPWR VPWR _5666_/D sky130_fd_sc_hd__a22o_1
X_3024_ _5933_/Q _3144_/B _2980_/Y _5942_/Q _2977_/Y VGND VGND VPWR VPWR _3024_/X
+ sky130_fd_sc_hd__a221o_1
XANTENNA__4815__A1 _3651_/B VGND VGND VPWR VPWR sky130_fd_sc_hd__diode_2
XFILLER_24_504 VPWR VGND VPWR VGND sky130_ef_sc_hd__decap_12
X_4975_ hold396/X _4975_/A2 _4974_/X VGND VGND VPWR VPWR _5934_/D sky130_fd_sc_hd__a21o_1
XANTENNA__4579__B1 _4667_/B1 VGND VGND VPWR VPWR sky130_fd_sc_hd__diode_2
X_3926_ _5589_/Q _3240_/B _3564_/A _3918_/X VGND VGND VPWR VPWR _5589_/D sky130_fd_sc_hd__a22o_1
X_3857_ _5427_/A _3905_/B _3905_/C VGND VGND VPWR VPWR _3857_/X sky130_fd_sc_hd__and3_1
Xclkload7 clkload7/A VGND VGND VPWR VPWR clkload7/Y sky130_fd_sc_hd__inv_12
X_2808_ _2805_/X _2806_/X _2807_/X _2803_/Y VGND VGND VPWR VPWR _2815_/C sky130_fd_sc_hd__o31a_1
X_3788_ _3916_/S _3811_/C _3786_/Y _3826_/S VGND VGND VPWR VPWR _3788_/Y sky130_fd_sc_hd__o31ai_1
XANTENNA__4751__A0 _5767_/Q VGND VGND VPWR VPWR sky130_fd_sc_hd__diode_2
X_2739_ _4943_/S VGND VGND VPWR VPWR _2993_/A sky130_fd_sc_hd__inv_2
X_5527_ _5645_/CLK _5527_/D VGND VGND VPWR VPWR hold61/A sky130_fd_sc_hd__dfxtp_1
XANTENNA__3284__A _5427_/A VGND VGND VPWR VPWR sky130_fd_sc_hd__diode_2
X_5458_ _6177_/Q _5458_/B _5458_/C VGND VGND VPWR VPWR _5458_/X sky130_fd_sc_hd__and3_1
Xfanout222 _2831_/B VGND VGND VPWR VPWR _2844_/D sky130_fd_sc_hd__clkbuf_2
X_4409_ _4407_/Y _4424_/B _4436_/S VGND VGND VPWR VPWR _4409_/X sky130_fd_sc_hd__o21a_1
X_5389_ hold370/X _5441_/B _5388_/X VGND VGND VPWR VPWR _6166_/D sky130_fd_sc_hd__a21o_1
Xfanout200 _6113_/Q VGND VGND VPWR VPWR _2864_/A sky130_fd_sc_hd__buf_2
Xfanout211 _6049_/Q VGND VGND VPWR VPWR _2977_/A sky130_fd_sc_hd__buf_2
XTAP_TAPCELL_ROW_70_1055 VGND VPWR sky130_fd_sc_hd__tapvpwrvgnd_1
XTAP_TAPCELL_ROW_6_257 VGND VPWR sky130_fd_sc_hd__tapvpwrvgnd_1
Xfanout233 _5749_/Q VGND VGND VPWR VPWR _4522_/C sky130_fd_sc_hd__buf_2
Xfanout244 _4447_/B VGND VGND VPWR VPWR _4444_/B sky130_fd_sc_hd__buf_2
Xfanout255 _5738_/Q VGND VGND VPWR VPWR _4829_/C sky130_fd_sc_hd__clkbuf_4
XFILLER_75_37 VPWR VGND VPWR VGND sky130_ef_sc_hd__decap_12
XFILLER_75_15 VGND VGND VPWR VPWR sky130_fd_sc_hd__decap_8
XFILLER_59_489 VGND VGND VPWR VPWR sky130_fd_sc_hd__fill_1
Xfanout299 fanout300/X VGND VGND VPWR VPWR fanout299/X sky130_fd_sc_hd__clkbuf_4
Xfanout288 fanout289/X VGND VGND VPWR VPWR fanout288/X sky130_fd_sc_hd__clkbuf_4
XFILLER_47_607 VGND VGND VPWR VPWR sky130_fd_sc_hd__decap_8
Xfanout266 _5609_/Q VGND VGND VPWR VPWR _3954_/A sky130_fd_sc_hd__clkbuf_4
Xfanout277 fanout279/X VGND VGND VPWR VPWR fanout277/X sky130_fd_sc_hd__clkbuf_4
XANTENNA__3223__S _3229_/S VGND VGND VPWR VPWR sky130_fd_sc_hd__diode_2
XFILLER_46_139 VGND VGND VPWR VPWR sky130_fd_sc_hd__fill_1
XANTENNA_fanout55_A _4686_/B1 VGND VGND VPWR VPWR sky130_fd_sc_hd__diode_2
XFILLER_55_673 VGND VGND VPWR VPWR sky130_fd_sc_hd__fill_1
XTAP_TAPCELL_ROW_53_841 VGND VPWR sky130_fd_sc_hd__tapvpwrvgnd_1
XFILLER_15_559 VGND VGND VPWR VPWR sky130_fd_sc_hd__fill_1
XFILLER_23_581 VGND VGND VPWR VPWR sky130_fd_sc_hd__fill_2
XANTENNA__4990__B1 _5038_/B1 VGND VGND VPWR VPWR sky130_fd_sc_hd__diode_2
XFILLER_10_253 VGND VGND VPWR VPWR sky130_fd_sc_hd__decap_4
XANTENNA__3746__X _3746_/X VGND VGND VPWR VPWR sky130_fd_sc_hd__diode_2
XFILLER_40_95 VGND VGND VPWR VPWR sky130_fd_sc_hd__decap_4
XFILLER_49_82 VGND VGND VPWR VPWR sky130_fd_sc_hd__fill_1
XANTENNA__4229__S _4232_/S VGND VGND VPWR VPWR sky130_fd_sc_hd__diode_2
XANTENNA__3641__B _4517_/A VGND VGND VPWR VPWR sky130_fd_sc_hd__diode_2
XFILLER_1_89 VGND VGND VPWR VPWR sky130_fd_sc_hd__decap_3
XANTENNA__4175__D _4175_/D VGND VGND VPWR VPWR sky130_fd_sc_hd__diode_2
XFILLER_80_429 VGND VGND VPWR VPWR sky130_fd_sc_hd__fill_1
XFILLER_33_367 VGND VGND VPWR VPWR sky130_fd_sc_hd__decap_4
XFILLER_60_197 VGND VGND VPWR VPWR sky130_fd_sc_hd__fill_1
XFILLER_14_581 VGND VGND VPWR VPWR sky130_fd_sc_hd__decap_6
X_4760_ _5799_/Q _5174_/A2 _4561_/B _3564_/B VGND VGND VPWR VPWR _5799_/D sky130_fd_sc_hd__a22o_1
X_4691_ _5927_/Q _4747_/A2 _4747_/B1 _4690_/X VGND VGND VPWR VPWR _4691_/X sky130_fd_sc_hd__a22o_1
X_3711_ _3711_/A _3711_/B _3711_/C _3711_/D VGND VGND VPWR VPWR _3723_/C sky130_fd_sc_hd__or4_1
XTAP_TAPCELL_ROW_31_568 VGND VPWR sky130_fd_sc_hd__tapvpwrvgnd_1
X_3642_ _4517_/A _6044_/Q VGND VGND VPWR VPWR _3645_/B sky130_fd_sc_hd__and2b_1
XANTENNA__4733__A0 _5765_/Q VGND VGND VPWR VPWR sky130_fd_sc_hd__diode_2
XPHY_EDGE_ROW_49_Right_49 VGND VGND VPWR VPWR sky130_fd_sc_hd__decap_3
X_5312_ _5318_/A _5312_/B VGND VGND VPWR VPWR _5315_/A sky130_fd_sc_hd__and2_1
X_3573_ _6103_/Q _3623_/A VGND VGND VPWR VPWR _3573_/Y sky130_fd_sc_hd__nand2_1
X_5243_ _3468_/B _3468_/C _3468_/D _2733_/Y VGND VGND VPWR VPWR _5244_/C sky130_fd_sc_hd__o31ai_1
Xhold19 hold19/A VGND VGND VPWR VPWR hold19/X sky130_fd_sc_hd__dlygate4sd3_1
X_5174_ _3150_/C _5174_/A2 _4561_/B _6163_/Q VGND VGND VPWR VPWR _6096_/D sky130_fd_sc_hd__a22o_1
XANTENNA__3832__A _5412_/A VGND VGND VPWR VPWR sky130_fd_sc_hd__diode_2
X_4125_ _5572_/Q _3810_/X _4104_/Y _4105_/Y _4106_/X VGND VGND VPWR VPWR _4126_/D
+ sky130_fd_sc_hd__a2111o_1
XTAP_TAPCELL_ROW_3_216 VGND VPWR sky130_fd_sc_hd__tapvpwrvgnd_1
XFILLER_28_139 VGND VGND VPWR VPWR sky130_fd_sc_hd__fill_1
XPHY_EDGE_ROW_58_Right_58 VGND VGND VPWR VPWR sky130_fd_sc_hd__decap_3
X_4056_ hold17/A hold28/A _4070_/S VGND VGND VPWR VPWR _4057_/B sky130_fd_sc_hd__mux2_1
XTAP_TAPCELL_ROW_39_668 VGND VPWR sky130_fd_sc_hd__tapvpwrvgnd_1
X_3007_ hold18/A hold43/A hold38/A hold47/A _3954_/A _3955_/A VGND VGND VPWR VPWR
+ _3007_/X sky130_fd_sc_hd__mux4_1
XFILLER_24_334 VPWR VGND VPWR VGND sky130_ef_sc_hd__decap_12
XANTENNA__3224__A0 _5094_/A1 VGND VGND VPWR VPWR sky130_fd_sc_hd__diode_2
XTAP_TAPCELL_ROW_50_800 VGND VPWR sky130_fd_sc_hd__tapvpwrvgnd_1
XANTENNA_fanout145_X _4950_/A2 VGND VGND VPWR VPWR sky130_fd_sc_hd__diode_2
XTAP_TAPCELL_ROW_50_811 VGND VPWR sky130_fd_sc_hd__tapvpwrvgnd_1
X_4958_ _5094_/A1 _4706_/X _4973_/S VGND VGND VPWR VPWR _4958_/X sky130_fd_sc_hd__mux2_1
X_4889_ _5796_/Q _5520_/Q _4901_/S VGND VGND VPWR VPWR _4889_/X sky130_fd_sc_hd__mux2_1
X_3909_ _5580_/Q _3908_/B _3758_/S VGND VGND VPWR VPWR _3909_/X sky130_fd_sc_hd__o21a_1
XPHY_EDGE_ROW_67_Right_67 VGND VGND VPWR VPWR sky130_fd_sc_hd__decap_3
XANTENNA__4724__B1 _4243_/S VGND VGND VPWR VPWR sky130_fd_sc_hd__diode_2
XANTENNA__3218__S _3219_/S VGND VGND VPWR VPWR sky130_fd_sc_hd__diode_2
XANTENNA__5923__RESET_B fanout307/X VGND VGND VPWR VPWR sky130_fd_sc_hd__diode_2
XTAP_TAPCELL_ROW_58_900 VGND VPWR sky130_fd_sc_hd__tapvpwrvgnd_1
XPHY_EDGE_ROW_76_Right_76 VGND VGND VPWR VPWR sky130_fd_sc_hd__decap_3
XTAP_TAPCELL_ROW_58_911 VGND VPWR sky130_fd_sc_hd__tapvpwrvgnd_1
XFILLER_19_106 VGND VGND VPWR VPWR sky130_fd_sc_hd__decap_6
XANTENNA_fanout58_X _5123_/B VGND VGND VPWR VPWR sky130_fd_sc_hd__diode_2
XANTENNA_clkbuf_leaf_52_clk_A clkload0/A VGND VGND VPWR VPWR sky130_fd_sc_hd__diode_2
XANTENNA__3189__A _3442_/S VGND VGND VPWR VPWR sky130_fd_sc_hd__diode_2
XANTENNA__4715__B1 _4747_/B1 VGND VGND VPWR VPWR sky130_fd_sc_hd__diode_2
XANTENNA__3195__Y _3203_/S VGND VGND VPWR VPWR sky130_fd_sc_hd__diode_2
XFILLER_51_83 VGND VGND VPWR VPWR sky130_fd_sc_hd__decap_3
XPHY_EDGE_ROW_2_Left_83 VGND VGND VPWR VPWR sky130_fd_sc_hd__decap_3
XANTENNA__3652__A _4464_/A VGND VGND VPWR VPWR sky130_fd_sc_hd__diode_2
XFILLER_65_223 VGND VGND VPWR VPWR sky130_fd_sc_hd__fill_1
XFILLER_76_91 VGND VGND VPWR VPWR sky130_fd_sc_hd__fill_2
X_5930_ _5966_/CLK _5930_/D fanout308/X VGND VGND VPWR VPWR _5930_/Q sky130_fd_sc_hd__dfrtp_1
XFILLER_19_673 VGND VGND VPWR VPWR sky130_fd_sc_hd__fill_2
XTAP_TAPCELL_ROW_36_627 VGND VPWR sky130_fd_sc_hd__tapvpwrvgnd_1
XFILLER_34_643 VGND VGND VPWR VPWR sky130_fd_sc_hd__fill_1
X_5861_ _6106_/CLK _5861_/D fanout274/X VGND VGND VPWR VPWR _5861_/Q sky130_fd_sc_hd__dfrtp_1
XANTENNA__3206__A0 _4970_/A0 VGND VGND VPWR VPWR sky130_fd_sc_hd__diode_2
X_5792_ _5792_/CLK _5792_/D fanout297/X VGND VGND VPWR VPWR _5792_/Q sky130_fd_sc_hd__dfrtp_1
XTAP_TAPCELL_ROW_16_384 VGND VPWR sky130_fd_sc_hd__tapvpwrvgnd_1
X_4812_ _4873_/A _4824_/A2 _4811_/X hold163/X VGND VGND VPWR VPWR _5848_/D sky130_fd_sc_hd__a22o_1
X_4743_ _5766_/Q _5933_/Q _4751_/S VGND VGND VPWR VPWR _4743_/X sky130_fd_sc_hd__mux2_1
X_4674_ _5473_/Q _5799_/Q _4674_/S VGND VGND VPWR VPWR _4674_/X sky130_fd_sc_hd__mux2_1
X_3625_ _4522_/B _5976_/Q VGND VGND VPWR VPWR _3718_/C sky130_fd_sc_hd__xor2_1
XANTENNA_fanout105_A _4878_/Y VGND VGND VPWR VPWR sky130_fd_sc_hd__diode_2
XFILLER_1_709 VGND VGND VPWR VPWR sky130_fd_sc_hd__decap_4
X_3556_ _3523_/B _3523_/C _3545_/A VGND VGND VPWR VPWR _3556_/X sky130_fd_sc_hd__a21o_1
X_3487_ _5226_/B _3487_/B VGND VGND VPWR VPWR _3491_/B sky130_fd_sc_hd__or2_1
X_5226_ _5230_/A _5226_/B _5226_/C _5226_/D VGND VGND VPWR VPWR _5226_/X sky130_fd_sc_hd__or4_1
X_5157_ hold118/X _5467_/Q _5170_/S VGND VGND VPWR VPWR _6079_/D sky130_fd_sc_hd__mux2_1
X_5088_ hold186/X _5471_/Q _5098_/S VGND VGND VPWR VPWR _6011_/D sky130_fd_sc_hd__mux2_1
X_4108_ _5577_/Q _4108_/B _4108_/C VGND VGND VPWR VPWR _4119_/D sky130_fd_sc_hd__and3_1
XANTENNA__4393__A _4408_/A VGND VGND VPWR VPWR sky130_fd_sc_hd__diode_2
X_4039_ _4074_/S1 _4039_/B VGND VGND VPWR VPWR _4039_/X sky130_fd_sc_hd__and2b_1
XFILLER_44_429 VGND VGND VPWR VPWR sky130_fd_sc_hd__fill_1
XANTENNA__2799__A2 _2916_/B VGND VGND VPWR VPWR sky130_fd_sc_hd__diode_2
XANTENNA__6122__RESET_B fanout313/X VGND VGND VPWR VPWR sky130_fd_sc_hd__diode_2
XFILLER_24_197 VGND VGND VPWR VPWR sky130_fd_sc_hd__fill_2
XANTENNA__5725__Q _5725_/Q VGND VGND VPWR VPWR sky130_fd_sc_hd__diode_2
XFILLER_21_42 VPWR VGND VPWR VGND sky130_ef_sc_hd__decap_12
XANTENNA__4173__A1 _5760_/Q VGND VGND VPWR VPWR sky130_fd_sc_hd__diode_2
XFILLER_79_315 VGND VGND VPWR VPWR sky130_fd_sc_hd__fill_1
XANTENNA__3920__B2 _3918_/X VGND VGND VPWR VPWR sky130_fd_sc_hd__diode_2
XANTENNA__5163__S _5167_/S VGND VGND VPWR VPWR sky130_fd_sc_hd__diode_2
XFILLER_47_212 VGND VGND VPWR VPWR sky130_fd_sc_hd__fill_1
XANTENNA__5425__A1 _6171_/Q VGND VGND VPWR VPWR sky130_fd_sc_hd__diode_2
XFILLER_46_61 VGND VGND VPWR VPWR sky130_fd_sc_hd__decap_4
XFILLER_46_83 VGND VGND VPWR VPWR sky130_fd_sc_hd__fill_1
XTAP_TAPCELL_ROW_61_939 VGND VPWR sky130_fd_sc_hd__tapvpwrvgnd_1
XFILLER_16_698 VGND VGND VPWR VPWR sky130_fd_sc_hd__fill_2
XFILLER_62_60 VGND VGND VPWR VPWR sky130_fd_sc_hd__decap_3
XANTENNA__3647__A _3647_/A VGND VGND VPWR VPWR sky130_fd_sc_hd__diode_2
XTAP_TAPCELL_ROW_13_343 VGND VPWR sky130_fd_sc_hd__tapvpwrvgnd_1
XFILLER_7_55 VGND VGND VPWR VPWR sky130_fd_sc_hd__fill_1
XTAP_TAPCELL_ROW_41_696 VGND VPWR sky130_fd_sc_hd__tapvpwrvgnd_1
Xhold308 _5829_/Q VGND VGND VPWR VPWR hold308/X sky130_fd_sc_hd__dlygate4sd3_1
XFILLER_7_88 VGND VGND VPWR VPWR sky130_fd_sc_hd__fill_1
X_3410_ hold36/X _5636_/Q _3416_/S VGND VGND VPWR VPWR _5526_/D sky130_fd_sc_hd__mux2_1
X_4390_ _4390_/A _4390_/B VGND VGND VPWR VPWR _4392_/A sky130_fd_sc_hd__nor2_1
Xhold319 _5611_/Q VGND VGND VPWR VPWR hold319/X sky130_fd_sc_hd__dlygate4sd3_1
X_3341_ _3357_/C _3341_/B _3354_/C _3354_/D VGND VGND VPWR VPWR _3341_/X sky130_fd_sc_hd__or4_1
XANTENNA__5073__S _5097_/S VGND VGND VPWR VPWR sky130_fd_sc_hd__diode_2
XFILLER_3_591 VGND VGND VPWR VPWR sky130_fd_sc_hd__fill_2
X_6060_ _6159_/CLK _6060_/D fanout282/X VGND VGND VPWR VPWR _6060_/Q sky130_fd_sc_hd__dfrtp_1
XFILLER_30_3 VGND VGND VPWR VPWR sky130_fd_sc_hd__decap_4
X_3272_ _5412_/A _3272_/B VGND VGND VPWR VPWR _3282_/C sky130_fd_sc_hd__nor2_1
X_5011_ hold435/X _5027_/A2 _5010_/X VGND VGND VPWR VPWR _5951_/D sky130_fd_sc_hd__a21o_1
XFILLER_66_587 VGND VGND VPWR VPWR sky130_fd_sc_hd__fill_1
XFILLER_26_418 VGND VGND VPWR VPWR sky130_fd_sc_hd__fill_2
XFILLER_38_289 VGND VGND VPWR VPWR sky130_fd_sc_hd__fill_2
XANTENNA__2726__A _5494_/Q VGND VGND VPWR VPWR sky130_fd_sc_hd__diode_2
XANTENNA__4624__C1 _4720_/C1 VGND VGND VPWR VPWR sky130_fd_sc_hd__diode_2
XTAP_TAPCELL_ROW_49_796 VGND VPWR sky130_fd_sc_hd__tapvpwrvgnd_1
XFILLER_19_470 VPWR VGND VPWR VGND sky130_ef_sc_hd__decap_12
X_5913_ _6142_/CLK _5913_/D fanout326/X VGND VGND VPWR VPWR _5913_/Q sky130_fd_sc_hd__dfrtp_1
X_5844_ _6093_/CLK _5844_/D fanout345/X VGND VGND VPWR VPWR _5844_/Q sky130_fd_sc_hd__dfrtp_1
XFILLER_22_657 VGND VGND VPWR VPWR sky130_fd_sc_hd__fill_2
X_5775_ _5966_/CLK _5775_/D fanout304/X VGND VGND VPWR VPWR _5775_/Q sky130_fd_sc_hd__dfrtp_1
X_2987_ _4977_/A _4232_/S VGND VGND VPWR VPWR _2987_/Y sky130_fd_sc_hd__nand2_2
XFILLER_21_167 VGND VGND VPWR VPWR sky130_fd_sc_hd__fill_1
XFILLER_21_178 VGND VGND VPWR VPWR sky130_fd_sc_hd__fill_1
X_4726_ _4750_/A1 _4725_/X _4724_/X _4750_/C1 VGND VGND VPWR VPWR _4726_/X sky130_fd_sc_hd__o211a_1
X_4657_ hold267/X _4745_/A2 _4656_/X VGND VGND VPWR VPWR _5780_/D sky130_fd_sc_hd__o21a_1
XANTENNA__3276__B _5200_/C VGND VGND VPWR VPWR sky130_fd_sc_hd__diode_2
X_3608_ _3647_/A _6059_/Q VGND VGND VPWR VPWR _3714_/B sky130_fd_sc_hd__and2b_1
X_4588_ _5947_/Q _4683_/A2 _4684_/A2 _5914_/Q _4587_/X VGND VGND VPWR VPWR _4588_/X
+ sky130_fd_sc_hd__a221o_1
XANTENNA__3902__A1 _3905_/A VGND VGND VPWR VPWR sky130_fd_sc_hd__diode_2
XANTENNA__4388__A _4408_/A VGND VGND VPWR VPWR sky130_fd_sc_hd__diode_2
X_3539_ _3509_/Y _3546_/B _3525_/X _3538_/Y _3508_/X VGND VGND VPWR VPWR _3539_/Y
+ sky130_fd_sc_hd__a311oi_1
XFILLER_76_329 VGND VGND VPWR VPWR sky130_fd_sc_hd__fill_1
X_5209_ _3928_/A _6129_/D _6128_/D VGND VGND VPWR VPWR _5210_/B sky130_fd_sc_hd__nand3b_1
XFILLER_57_576 VGND VGND VPWR VPWR sky130_fd_sc_hd__fill_1
XFILLER_57_565 VGND VGND VPWR VPWR sky130_fd_sc_hd__fill_1
XFILLER_72_546 VGND VGND VPWR VPWR sky130_fd_sc_hd__fill_1
XTAP_TAPCELL_ROW_67_1016 VGND VPWR sky130_fd_sc_hd__tapvpwrvgnd_1
XANTENNA__3969__A1 _5599_/Q VGND VGND VPWR VPWR sky130_fd_sc_hd__diode_2
XFILLER_13_613 VGND VGND VPWR VPWR sky130_fd_sc_hd__decap_3
XFILLER_25_473 VGND VGND VPWR VPWR sky130_fd_sc_hd__decap_4
XFILLER_9_617 VGND VGND VPWR VPWR sky130_fd_sc_hd__decap_6
XFILLER_40_421 VGND VGND VPWR VPWR sky130_fd_sc_hd__fill_2
XFILLER_8_105 VGND VGND VPWR VPWR sky130_fd_sc_hd__fill_2
XANTENNA__5158__S _5166_/S VGND VGND VPWR VPWR sky130_fd_sc_hd__diode_2
XTAP_TAPCELL_ROW_10_302 VGND VPWR sky130_fd_sc_hd__tapvpwrvgnd_1
XTAP_TAPCELL_ROW_78_1156 VGND VPWR sky130_fd_sc_hd__tapvpwrvgnd_1
XANTENNA__3406__S _3407_/S VGND VGND VPWR VPWR sky130_fd_sc_hd__diode_2
XANTENNA__3930__A _6129_/D VGND VGND VPWR VPWR sky130_fd_sc_hd__diode_2
XFILLER_48_587 VGND VGND VPWR VPWR sky130_fd_sc_hd__fill_1
XFILLER_63_524 VGND VGND VPWR VPWR sky130_fd_sc_hd__decap_4
XTAP_TAPCELL_ROW_18_402 VGND VPWR sky130_fd_sc_hd__tapvpwrvgnd_1
XANTENNA_clkload0_A clkload0/A VGND VGND VPWR VPWR sky130_fd_sc_hd__diode_2
XFILLER_35_237 VPWR VGND VPWR VGND sky130_ef_sc_hd__decap_12
XTAP_TAPCELL_ROW_46_755 VGND VPWR sky130_fd_sc_hd__tapvpwrvgnd_1
XFILLER_73_81 VPWR VGND VPWR VGND sky130_ef_sc_hd__decap_12
X_2910_ _5831_/Q _2910_/B VGND VGND VPWR VPWR _2910_/X sky130_fd_sc_hd__and2_1
X_3890_ _5514_/Q _3913_/B VGND VGND VPWR VPWR _3890_/X sky130_fd_sc_hd__or2_1
XFILLER_43_281 VGND VGND VPWR VPWR sky130_fd_sc_hd__fill_1
X_2841_ _6129_/Q _2908_/B VGND VGND VPWR VPWR _2841_/X sky130_fd_sc_hd__and2_1
XFILLER_31_465 VPWR VGND VPWR VGND sky130_ef_sc_hd__decap_12
XANTENNA__5068__S _5097_/S VGND VGND VPWR VPWR sky130_fd_sc_hd__diode_2
XFILLER_78_3 VGND VGND VPWR VPWR sky130_fd_sc_hd__fill_2
X_2772_ _4093_/A _4247_/B VGND VGND VPWR VPWR _4320_/A sky130_fd_sc_hd__nand2_2
X_5560_ _5697_/CLK _5560_/D VGND VGND VPWR VPWR hold33/A sky130_fd_sc_hd__dfxtp_1
X_5491_ _6144_/CLK _5491_/D fanout331/X VGND VGND VPWR VPWR _5491_/Q sky130_fd_sc_hd__dfrtp_4
X_4511_ _3479_/X _4507_/Y _4510_/X VGND VGND VPWR VPWR _4511_/X sky130_fd_sc_hd__a21o_1
X_4442_ _4442_/A _4442_/B VGND VGND VPWR VPWR _4443_/B sky130_fd_sc_hd__xnor2_1
Xhold116 _5853_/Q VGND VGND VPWR VPWR hold116/X sky130_fd_sc_hd__dlygate4sd3_1
Xhold105 _5814_/Q VGND VGND VPWR VPWR hold105/X sky130_fd_sc_hd__dlygate4sd3_1
Xhold149 _5506_/Q VGND VGND VPWR VPWR hold149/X sky130_fd_sc_hd__dlygate4sd3_1
Xhold127 _5812_/Q VGND VGND VPWR VPWR hold127/X sky130_fd_sc_hd__dlygate4sd3_1
Xhold138 _5994_/Q VGND VGND VPWR VPWR hold138/X sky130_fd_sc_hd__dlygate4sd3_1
X_4373_ _4829_/C _4475_/B VGND VGND VPWR VPWR _4373_/Y sky130_fd_sc_hd__nand2_1
X_3324_ _3749_/A _3362_/D _6046_/Q VGND VGND VPWR VPWR _3325_/D sky130_fd_sc_hd__or3b_1
X_6112_ _6113_/CLK _6112_/D fanout335/X VGND VGND VPWR VPWR _6112_/Q sky130_fd_sc_hd__dfrtp_1
X_6043_ _6106_/CLK _6043_/D fanout274/X VGND VGND VPWR VPWR _6043_/Q sky130_fd_sc_hd__dfrtp_1
X_3255_ _6125_/Q _6127_/Q _6126_/Q VGND VGND VPWR VPWR _3454_/D sky130_fd_sc_hd__or3b_1
XFILLER_39_521 VGND VGND VPWR VPWR sky130_fd_sc_hd__fill_1
X_3186_ _3186_/A _3443_/C VGND VGND VPWR VPWR _5465_/D sky130_fd_sc_hd__xnor2_1
XFILLER_39_554 VGND VGND VPWR VPWR sky130_fd_sc_hd__decap_6
XFILLER_39_565 VGND VGND VPWR VPWR sky130_fd_sc_hd__fill_1
XFILLER_66_384 VGND VGND VPWR VPWR sky130_fd_sc_hd__fill_1
XANTENNA__4612__A2 _4684_/A2 VGND VGND VPWR VPWR sky130_fd_sc_hd__diode_2
XFILLER_22_421 VPWR VGND VPWR VGND sky130_ef_sc_hd__decap_12
XFILLER_34_281 VPWR VGND VPWR VGND sky130_ef_sc_hd__decap_12
X_5827_ _6094_/CLK _5827_/D fanout349/X VGND VGND VPWR VPWR _5827_/Q sky130_fd_sc_hd__dfrtp_1
X_5758_ _6111_/CLK _5758_/D fanout327/X VGND VGND VPWR VPWR _5758_/Q sky130_fd_sc_hd__dfrtp_1
XANTENNA__2926__A2 _2910_/B VGND VGND VPWR VPWR sky130_fd_sc_hd__diode_2
X_4709_ _5762_/Q _5962_/Q _4735_/S VGND VGND VPWR VPWR _4709_/X sky130_fd_sc_hd__mux2_1
X_5689_ _5690_/CLK _5689_/D fanout317/X VGND VGND VPWR VPWR _5689_/Q sky130_fd_sc_hd__dfrtp_1
XANTENNA__3226__S _3229_/S VGND VGND VPWR VPWR sky130_fd_sc_hd__diode_2
XFILLER_76_115 VGND VGND VPWR VPWR sky130_fd_sc_hd__fill_1
XTAP_TAPCELL_ROW_73_1097 VGND VPWR sky130_fd_sc_hd__tapvpwrvgnd_1
XFILLER_17_237 VPWR VGND VPWR VGND sky130_ef_sc_hd__decap_12
XANTENNA__4603__A2 _4684_/A2 VGND VGND VPWR VPWR sky130_fd_sc_hd__diode_2
XTAP_TAPCELL_ROW_43_714 VGND VPWR sky130_fd_sc_hd__tapvpwrvgnd_1
XFILLER_13_421 VPWR VGND VPWR VGND sky130_ef_sc_hd__decap_12
XFILLER_40_251 VGND VGND VPWR VPWR sky130_fd_sc_hd__fill_1
XFILLER_9_447 VGND VGND VPWR VPWR sky130_fd_sc_hd__fill_1
XTAP_TAPCELL_ROW_23_471 VGND VPWR sky130_fd_sc_hd__tapvpwrvgnd_1
XFILLER_40_284 VPWR VGND VPWR VGND sky130_ef_sc_hd__decap_12
XANTENNA__2917__A2 _2917_/A2 VGND VGND VPWR VPWR sky130_fd_sc_hd__diode_2
XFILLER_9_469 VGND VGND VPWR VPWR sky130_fd_sc_hd__fill_1
XFILLER_4_185 VGND VGND VPWR VPWR sky130_fd_sc_hd__decap_8
XFILLER_68_70 VPWR VGND VPWR VGND sky130_ef_sc_hd__decap_12
XFILLER_68_92 VGND VGND VPWR VPWR sky130_fd_sc_hd__fill_1
X_3040_ _5926_/Q _2978_/Y _3038_/X _3039_/X VGND VGND VPWR VPWR _3040_/X sky130_fd_sc_hd__o22a_1
XFILLER_48_362 VGND VGND VPWR VPWR sky130_fd_sc_hd__fill_2
XANTENNA__4475__B _4475_/B VGND VGND VPWR VPWR sky130_fd_sc_hd__diode_2
X_4991_ hold409/X _5043_/A2 _4990_/X VGND VGND VPWR VPWR _5941_/D sky130_fd_sc_hd__a21o_1
X_3942_ _5600_/Q _3549_/Y _5353_/A VGND VGND VPWR VPWR _5600_/D sky130_fd_sc_hd__mux2_1
X_3873_ _5577_/Q _3883_/C _3773_/A VGND VGND VPWR VPWR _3873_/Y sky130_fd_sc_hd__o21ai_1
XFILLER_31_262 VPWR VGND VPWR VGND sky130_ef_sc_hd__decap_12
X_2824_ _2844_/D _2830_/C _2824_/C _2844_/C VGND VGND VPWR VPWR _2824_/X sky130_fd_sc_hd__or4b_1
X_5612_ _5645_/CLK _5612_/D fanout315/X VGND VGND VPWR VPWR _5612_/Q sky130_fd_sc_hd__dfrtp_1
X_5543_ _5696_/CLK _5543_/D VGND VGND VPWR VPWR hold22/A sky130_fd_sc_hd__dfxtp_1
XANTENNA__3030__A1 _5523_/Q VGND VGND VPWR VPWR sky130_fd_sc_hd__diode_2
X_2755_ _6174_/Q VGND VGND VPWR VPWR _5442_/A sky130_fd_sc_hd__inv_2
X_5474_ _6021_/CLK _5474_/D fanout332/X VGND VGND VPWR VPWR _5474_/Q sky130_fd_sc_hd__dfrtp_4
X_4425_ _4527_/S _4423_/Y _4447_/C _4422_/X VGND VGND VPWR VPWR _4425_/X sky130_fd_sc_hd__o31a_1
X_4356_ _5353_/B _4475_/B VGND VGND VPWR VPWR _4462_/A sky130_fd_sc_hd__nor2_2
X_3307_ _5979_/Q _6165_/Q VGND VGND VPWR VPWR _3365_/A sky130_fd_sc_hd__and2b_1
X_4287_ _5712_/Q _4265_/X _4286_/X _4252_/X VGND VGND VPWR VPWR _4287_/X sky130_fd_sc_hd__a22o_1
XFILLER_67_671 VGND VGND VPWR VPWR sky130_fd_sc_hd__fill_1
X_3238_ _5642_/Q hold29/X _3238_/S VGND VGND VPWR VPWR _5502_/D sky130_fd_sc_hd__mux2_1
X_6026_ _6026_/CLK _6026_/D fanout280/X VGND VGND VPWR VPWR _6026_/Q sky130_fd_sc_hd__dfrtp_1
XANTENNA_fanout175_X _2918_/B1 VGND VGND VPWR VPWR sky130_fd_sc_hd__diode_2
X_3169_ _5522_/Q _5492_/Q _5472_/Q _4967_/A0 _3150_/B _3150_/C VGND VGND VPWR VPWR
+ _3169_/X sky130_fd_sc_hd__mux4_1
XFILLER_54_321 VGND VGND VPWR VPWR sky130_fd_sc_hd__fill_1
XFILLER_66_192 VGND VGND VPWR VPWR sky130_fd_sc_hd__decap_4
XTAP_TAPCELL_ROW_1_188 VGND VPWR sky130_fd_sc_hd__tapvpwrvgnd_1
XANTENNA__4597__A1 _5764_/Q VGND VGND VPWR VPWR sky130_fd_sc_hd__diode_2
Xfanout22 _3730_/X VGND VGND VPWR VPWR _4331_/A1 sky130_fd_sc_hd__clkbuf_2
Xfanout11 _5249_/X VGND VGND VPWR VPWR _5341_/B2 sky130_fd_sc_hd__buf_2
XFILLER_80_27 VGND VGND VPWR VPWR sky130_fd_sc_hd__fill_1
Xfanout55 _4686_/B1 VGND VGND VPWR VPWR _4678_/C1 sky130_fd_sc_hd__clkbuf_4
Xfanout44 _4740_/B1 VGND VGND VPWR VPWR _4243_/S sky130_fd_sc_hd__clkbuf_4
Xfanout33 _4865_/A VGND VGND VPWR VPWR _3906_/A2 sky130_fd_sc_hd__clkbuf_4
Xfanout99 _5170_/S VGND VGND VPWR VPWR _5172_/S sky130_fd_sc_hd__clkbuf_4
Xfanout66 _4753_/A2 VGND VGND VPWR VPWR _4745_/A2 sky130_fd_sc_hd__buf_2
Xfanout88 _5376_/B VGND VGND VPWR VPWR _5453_/B sky130_fd_sc_hd__buf_2
Xfanout77 _4828_/B2 VGND VGND VPWR VPWR _4870_/A1 sky130_fd_sc_hd__clkbuf_2
XANTENNA__5010__A2 _5024_/A2 VGND VGND VPWR VPWR sky130_fd_sc_hd__diode_2
XFILLER_10_446 VPWR VGND VPWR VGND sky130_ef_sc_hd__decap_12
XTAP_TAPCELL_ROW_20_430 VGND VPWR sky130_fd_sc_hd__tapvpwrvgnd_1
XFILLER_6_428 VPWR VGND VPWR VGND sky130_ef_sc_hd__decap_12
XTAP_TAPCELL_ROW_75_1115 VGND VPWR sky130_fd_sc_hd__tapvpwrvgnd_1
XFILLER_8_3 VGND VGND VPWR VPWR sky130_fd_sc_hd__fill_2
XFILLER_2_634 VGND VGND VPWR VPWR sky130_fd_sc_hd__decap_8
XFILLER_2_645 VPWR VGND VPWR VGND sky130_ef_sc_hd__decap_12
XTAP_TAPCELL_ROW_9_288 VGND VPWR sky130_fd_sc_hd__tapvpwrvgnd_1
XANTENNA__5171__S _5172_/S VGND VGND VPWR VPWR sky130_fd_sc_hd__diode_2
XFILLER_1_177 VGND VGND VPWR VPWR sky130_fd_sc_hd__decap_8
XFILLER_64_107 VGND VGND VPWR VPWR sky130_fd_sc_hd__decap_3
XANTENNA__2835__A1 _5491_/Q VGND VGND VPWR VPWR sky130_fd_sc_hd__diode_2
XFILLER_45_310 VGND VGND VPWR VPWR sky130_fd_sc_hd__fill_2
XTAP_TAPCELL_ROW_28_530 VGND VPWR sky130_fd_sc_hd__tapvpwrvgnd_1
XTAP_TAPCELL_ROW_56_883 VGND VPWR sky130_fd_sc_hd__tapvpwrvgnd_1
XFILLER_33_505 VGND VGND VPWR VPWR sky130_fd_sc_hd__decap_4
XANTENNA__5200__A _5369_/A VGND VGND VPWR VPWR sky130_fd_sc_hd__diode_2
XFILLER_41_571 VGND VGND VPWR VPWR sky130_fd_sc_hd__fill_1
XANTENNA__5001__A2 _5027_/A2 VGND VGND VPWR VPWR sky130_fd_sc_hd__diode_2
Xclkload25 _5967_/CLK VGND VGND VPWR VPWR clkload25/Y sky130_fd_sc_hd__inv_12
Xclkload14 _6110_/CLK VGND VGND VPWR VPWR clkload14/Y sky130_fd_sc_hd__inv_8
Xclkload47 _6091_/CLK VGND VGND VPWR VPWR clkload47/Y sky130_fd_sc_hd__clkinvlp_4
Xclkload36 _5635_/CLK VGND VGND VPWR VPWR clkload36/Y sky130_fd_sc_hd__clkinv_4
XANTENNA__4760__B2 _3564_/B VGND VGND VPWR VPWR sky130_fd_sc_hd__diode_2
XANTENNA__4760__A1 _5799_/Q VGND VGND VPWR VPWR sky130_fd_sc_hd__diode_2
X_4210_ hold117/X _4209_/X _4246_/S VGND VGND VPWR VPWR _5705_/D sky130_fd_sc_hd__mux2_1
XANTENNA__3321__A_N _5447_/A VGND VGND VPWR VPWR sky130_fd_sc_hd__diode_2
X_5190_ _2871_/B _5192_/A2 _4539_/X _6109_/Q VGND VGND VPWR VPWR _6111_/D sky130_fd_sc_hd__a22o_1
X_4141_ _4151_/B _4141_/B VGND VGND VPWR VPWR _4141_/X sky130_fd_sc_hd__and2b_1
XANTENNA__5081__S _5096_/S VGND VGND VPWR VPWR sky130_fd_sc_hd__diode_2
X_4072_ hold476/X _4541_/S _3976_/A VGND VGND VPWR VPWR _4072_/X sky130_fd_sc_hd__a21o_1
X_3023_ _5950_/Q _3153_/B _3022_/X VGND VGND VPWR VPWR _3023_/X sky130_fd_sc_hd__o21a_1
XFILLER_64_630 VGND VGND VPWR VPWR sky130_fd_sc_hd__fill_1
XFILLER_24_516 VPWR VGND VPWR VGND sky130_ef_sc_hd__decap_12
X_4974_ _4751_/X _4878_/A _4878_/B _4973_/X VGND VGND VPWR VPWR _4974_/X sky130_fd_sc_hd__a22o_1
XANTENNA__2734__A _5599_/Q VGND VGND VPWR VPWR sky130_fd_sc_hd__diode_2
X_3925_ _5588_/Q _2955_/Y _3536_/Y _3918_/X VGND VGND VPWR VPWR _5588_/D sky130_fd_sc_hd__a22o_1
XFILLER_32_571 VGND VGND VPWR VPWR sky130_fd_sc_hd__fill_1
XTAP_TAPCELL_ROW_34_599 VGND VPWR sky130_fd_sc_hd__tapvpwrvgnd_1
Xclkload8 clkload8/A VGND VGND VPWR VPWR clkload8/Y sky130_fd_sc_hd__inv_6
X_3856_ _3906_/A1 _3906_/A2 _3855_/X _3767_/A _3386_/X VGND VGND VPWR VPWR _4102_/B
+ sky130_fd_sc_hd__a32oi_4
X_2807_ _5883_/Q _2783_/B _2921_/B1 _5871_/Q _2804_/X VGND VGND VPWR VPWR _2807_/X
+ sky130_fd_sc_hd__a221o_1
X_3787_ _4098_/B _4098_/C _4098_/D _3916_/S VGND VGND VPWR VPWR _3787_/X sky130_fd_sc_hd__o31a_1
XANTENNA_fanout302_A fanout303/X VGND VGND VPWR VPWR sky130_fd_sc_hd__diode_2
X_5526_ _5635_/CLK _5526_/D VGND VGND VPWR VPWR hold36/A sky130_fd_sc_hd__dfxtp_1
X_2738_ _5863_/Q VGND VGND VPWR VPWR _4175_/A sky130_fd_sc_hd__inv_2
XANTENNA__6147__RESET_B fanout310/X VGND VGND VPWR VPWR sky130_fd_sc_hd__diode_2
X_5457_ _3905_/A _5442_/B _5376_/C _5456_/X VGND VGND VPWR VPWR _6176_/D sky130_fd_sc_hd__a31o_1
X_4408_ _4408_/A _5740_/Q _4408_/C VGND VGND VPWR VPWR _4424_/B sky130_fd_sc_hd__and3_1
Xfanout201 _6113_/Q VGND VGND VPWR VPWR _2895_/A sky130_fd_sc_hd__buf_2
Xfanout223 _2831_/B VGND VGND VPWR VPWR _2934_/A sky130_fd_sc_hd__dlymetal6s2s_1
Xfanout212 _3130_/A VGND VGND VPWR VPWR _3129_/B sky130_fd_sc_hd__buf_2
X_5388_ _5387_/A _5387_/B _5387_/Y _5410_/C VGND VGND VPWR VPWR _5388_/X sky130_fd_sc_hd__o211a_1
Xfanout256 _5728_/Q VGND VGND VPWR VPWR _2934_/B sky130_fd_sc_hd__clkbuf_4
X_4339_ _5701_/Q _4266_/A _4136_/X _5458_/C VGND VGND VPWR VPWR _4340_/C sky130_fd_sc_hd__o31ai_1
XTAP_TAPCELL_ROW_70_1056 VGND VPWR sky130_fd_sc_hd__tapvpwrvgnd_1
XANTENNA_fanout292_X fanout292/X VGND VGND VPWR VPWR sky130_fd_sc_hd__diode_2
XTAP_TAPCELL_ROW_6_258 VGND VPWR sky130_fd_sc_hd__tapvpwrvgnd_1
Xfanout245 _5743_/Q VGND VGND VPWR VPWR _4447_/B sky130_fd_sc_hd__clkbuf_4
Xfanout234 _3647_/A VGND VGND VPWR VPWR _4522_/B sky130_fd_sc_hd__buf_2
Xfanout289 fanout292/X VGND VGND VPWR VPWR fanout289/X sky130_fd_sc_hd__clkbuf_4
Xfanout267 _5590_/Q VGND VGND VPWR VPWR _3953_/B sky130_fd_sc_hd__buf_2
Xfanout278 fanout279/X VGND VGND VPWR VPWR fanout278/X sky130_fd_sc_hd__clkbuf_4
XFILLER_75_49 VGND VGND VPWR VPWR sky130_fd_sc_hd__decap_6
X_6009_ _6085_/CLK _6009_/D fanout342/X VGND VGND VPWR VPWR _6009_/Q sky130_fd_sc_hd__dfrtp_1
XFILLER_39_181 VPWR VGND VPWR VGND sky130_ef_sc_hd__decap_12
XANTENNA_fanout48_A _3877_/S VGND VGND VPWR VPWR sky130_fd_sc_hd__diode_2
XFILLER_15_505 VGND VGND VPWR VPWR sky130_fd_sc_hd__fill_2
XFILLER_54_195 VGND VGND VPWR VPWR sky130_fd_sc_hd__fill_1
XTAP_TAPCELL_ROW_53_842 VGND VPWR sky130_fd_sc_hd__tapvpwrvgnd_1
XANTENNA__5728__Q _5728_/Q VGND VGND VPWR VPWR sky130_fd_sc_hd__diode_2
XFILLER_10_210 VGND VGND VPWR VPWR sky130_fd_sc_hd__fill_2
XANTENNA__4990__B2 _4895_/X VGND VGND VPWR VPWR sky130_fd_sc_hd__diode_2
XFILLER_10_232 VGND VGND VPWR VPWR sky130_fd_sc_hd__decap_6
XFILLER_10_265 VGND VGND VPWR VPWR sky130_fd_sc_hd__decap_8
XANTENNA__5166__S _5166_/S VGND VGND VPWR VPWR sky130_fd_sc_hd__diode_2
XANTENNA__4742__A1 _4750_/A1 VGND VGND VPWR VPWR sky130_fd_sc_hd__diode_2
XFILLER_27_9 VGND VGND VPWR VPWR sky130_fd_sc_hd__fill_1
XFILLER_1_57 VPWR VGND VPWR VGND sky130_ef_sc_hd__decap_12
XFILLER_18_365 VPWR VGND VPWR VGND sky130_ef_sc_hd__decap_12
XANTENNA__3481__A1 _6130_/D VGND VGND VPWR VPWR sky130_fd_sc_hd__diode_2
XFILLER_33_313 VPWR VGND VPWR VGND sky130_ef_sc_hd__decap_12
X_3710_ _3710_/A _3710_/B _3710_/C _3710_/D VGND VGND VPWR VPWR _3711_/D sky130_fd_sc_hd__or4_1
X_4690_ _5793_/Q _5725_/Q _4746_/S VGND VGND VPWR VPWR _4690_/X sky130_fd_sc_hd__mux2_1
XANTENNA__5076__S _5098_/S VGND VGND VPWR VPWR sky130_fd_sc_hd__diode_2
X_3641_ _6044_/Q _4517_/A VGND VGND VPWR VPWR _3698_/A sky130_fd_sc_hd__and2b_1
XTAP_TAPCELL_ROW_31_569 VGND VPWR sky130_fd_sc_hd__tapvpwrvgnd_1
XFILLER_60_3 VPWR VGND VPWR VGND sky130_ef_sc_hd__decap_12
X_3572_ _6107_/Q _4517_/A VGND VGND VPWR VPWR _3708_/C sky130_fd_sc_hd__xor2_1
X_5311_ _6155_/Q _5342_/B VGND VGND VPWR VPWR _5312_/B sky130_fd_sc_hd__or2_1
X_5242_ _3462_/X _3475_/Y _5210_/B _5211_/X VGND VGND VPWR VPWR _5244_/B sky130_fd_sc_hd__o2bb2a_1
X_5173_ _3150_/B _5174_/A2 _4561_/B _6162_/Q VGND VGND VPWR VPWR _6095_/D sky130_fd_sc_hd__a22o_1
X_4124_ _4124_/A _4124_/B _4124_/C _4124_/D VGND VGND VPWR VPWR _4126_/C sky130_fd_sc_hd__or4_1
XTAP_TAPCELL_ROW_3_217 VGND VPWR sky130_fd_sc_hd__tapvpwrvgnd_1
Xinput1 rst_n VGND VGND VPWR VPWR input1/X sky130_fd_sc_hd__clkbuf_2
Xclkbuf_leaf_48_clk clkload1/A VGND VGND VPWR VPWR _6176_/CLK sky130_fd_sc_hd__clkbuf_8
XFILLER_37_652 VGND VGND VPWR VPWR sky130_fd_sc_hd__fill_1
XTAP_TAPCELL_ROW_39_669 VGND VPWR sky130_fd_sc_hd__tapvpwrvgnd_1
X_4055_ hold52/X _3975_/Y _4053_/X _4054_/X VGND VGND VPWR VPWR _5663_/D sky130_fd_sc_hd__a22o_1
XFILLER_52_600 VGND VGND VPWR VPWR sky130_fd_sc_hd__fill_1
X_3006_ _5676_/Q _5594_/Q _2958_/X _5603_/Q VGND VGND VPWR VPWR _3006_/X sky130_fd_sc_hd__a22o_1
XANTENNA_fanout252_A _4813_/A1 VGND VGND VPWR VPWR sky130_fd_sc_hd__diode_2
XFILLER_36_173 VGND VGND VPWR VPWR sky130_fd_sc_hd__fill_1
XFILLER_36_184 VGND VGND VPWR VPWR sky130_fd_sc_hd__fill_1
XTAP_TAPCELL_ROW_50_801 VGND VPWR sky130_fd_sc_hd__tapvpwrvgnd_1
XFILLER_24_346 VGND VGND VPWR VPWR sky130_fd_sc_hd__decap_6
XANTENNA__3224__A1 _5489_/Q VGND VGND VPWR VPWR sky130_fd_sc_hd__diode_2
XFILLER_51_165 VGND VGND VPWR VPWR sky130_fd_sc_hd__decap_3
X_4957_ hold430/X _4975_/A2 _4956_/X VGND VGND VPWR VPWR _5928_/D sky130_fd_sc_hd__a21o_1
X_3908_ _5580_/Q _3908_/B VGND VGND VPWR VPWR _3912_/B sky130_fd_sc_hd__nand2_1
X_4888_ _5905_/Q _4975_/A2 _4887_/X VGND VGND VPWR VPWR _5905_/D sky130_fd_sc_hd__a21o_1
X_3839_ _3887_/A _5855_/Q VGND VGND VPWR VPWR _3839_/X sky130_fd_sc_hd__and2_1
XFILLER_3_206 VGND VGND VPWR VPWR sky130_fd_sc_hd__decap_3
X_5509_ _5811_/CLK _5509_/D fanout288/X VGND VGND VPWR VPWR _5509_/Q sky130_fd_sc_hd__dfrtp_1
XANTENNA__4488__B1 _3626_/A VGND VGND VPWR VPWR sky130_fd_sc_hd__diode_2
XANTENNA__3160__A0 _5521_/Q VGND VGND VPWR VPWR sky130_fd_sc_hd__diode_2
XTAP_TAPCELL_ROW_58_901 VGND VPWR sky130_fd_sc_hd__tapvpwrvgnd_1
XFILLER_59_276 VGND VGND VPWR VPWR sky130_fd_sc_hd__fill_1
Xclkbuf_leaf_39_clk clkload1/A VGND VGND VPWR VPWR _5686_/CLK sky130_fd_sc_hd__clkbuf_8
XFILLER_62_419 VGND VGND VPWR VPWR sky130_fd_sc_hd__fill_1
XANTENNA__4660__B1 _4740_/B1 VGND VGND VPWR VPWR sky130_fd_sc_hd__diode_2
XANTENNA__2816__D_N _5719_/Q VGND VGND VPWR VPWR sky130_fd_sc_hd__diode_2
XFILLER_32_7 VGND VGND VPWR VPWR sky130_fd_sc_hd__fill_1
XFILLER_78_563 VGND VGND VPWR VPWR sky130_fd_sc_hd__fill_1
XANTENNA__3151__B1 _3138_/B VGND VGND VPWR VPWR sky130_fd_sc_hd__diode_2
XFILLER_19_663 VGND VGND VPWR VPWR sky130_fd_sc_hd__fill_2
X_5860_ _6026_/CLK _5860_/D fanout280/X VGND VGND VPWR VPWR _5860_/Q sky130_fd_sc_hd__dfrtp_1
XTAP_TAPCELL_ROW_36_628 VGND VPWR sky130_fd_sc_hd__tapvpwrvgnd_1
X_4811_ _2719_/Y _3396_/X _4823_/A2 VGND VGND VPWR VPWR _4811_/X sky130_fd_sc_hd__o21ba_1
XFILLER_33_121 VGND VGND VPWR VPWR sky130_fd_sc_hd__decap_3
XFILLER_33_154 VGND VGND VPWR VPWR sky130_fd_sc_hd__fill_2
X_5791_ _5966_/CLK _5791_/D fanout304/X VGND VGND VPWR VPWR _5791_/Q sky130_fd_sc_hd__dfrtp_1
XTAP_TAPCELL_ROW_16_374 VGND VPWR sky130_fd_sc_hd__tapvpwrvgnd_1
XFILLER_34_699 VGND VGND VPWR VPWR sky130_fd_sc_hd__fill_1
X_4742_ _4750_/A1 _4741_/X _4740_/X _4750_/C1 VGND VGND VPWR VPWR _4742_/X sky130_fd_sc_hd__o211a_1
XTAP_TAPCELL_ROW_16_385 VGND VPWR sky130_fd_sc_hd__tapvpwrvgnd_1
XANTENNA__4703__S _4735_/S VGND VGND VPWR VPWR sky130_fd_sc_hd__diode_2
X_4673_ hold211/X _4737_/A2 _4672_/X VGND VGND VPWR VPWR _5782_/D sky130_fd_sc_hd__o21a_1
XANTENNA__4706__A1 _5727_/Q VGND VGND VPWR VPWR sky130_fd_sc_hd__diode_2
X_3624_ _4428_/A _5970_/Q _3623_/Y _4873_/B _4873_/A VGND VGND VPWR VPWR _3633_/A
+ sky130_fd_sc_hd__o2111ai_1
X_3555_ _3552_/Y _3553_/X _3550_/Y _3551_/X VGND VGND VPWR VPWR _3555_/X sky130_fd_sc_hd__o211a_1
X_3486_ _3530_/A _3486_/B _3488_/B VGND VGND VPWR VPWR _5247_/B sky130_fd_sc_hd__or3_1
XANTENNA__5131__A1 _4444_/B VGND VGND VPWR VPWR sky130_fd_sc_hd__diode_2
X_5225_ _5231_/A _5204_/B _6128_/D VGND VGND VPWR VPWR _5226_/D sky130_fd_sc_hd__o21a_1
X_5156_ hold220/X _5494_/Q _5172_/S VGND VGND VPWR VPWR _6078_/D sky130_fd_sc_hd__mux2_1
X_5087_ hold219/X _5470_/Q _5099_/S VGND VGND VPWR VPWR _6010_/D sky130_fd_sc_hd__mux2_1
XFILLER_29_449 VPWR VGND VPWR VGND sky130_ef_sc_hd__decap_12
X_4107_ _4108_/B _4108_/C _5577_/Q VGND VGND VPWR VPWR _4119_/C sky130_fd_sc_hd__a21oi_1
XANTENNA__4642__A0 _5469_/Q VGND VGND VPWR VPWR sky130_fd_sc_hd__diode_2
XFILLER_56_268 VGND VGND VPWR VPWR sky130_fd_sc_hd__fill_1
X_4038_ hold34/A hold60/A _4052_/S VGND VGND VPWR VPWR _4039_/B sky130_fd_sc_hd__mux2_1
XFILLER_37_471 VGND VGND VPWR VPWR sky130_fd_sc_hd__decap_4
XFILLER_72_39 VGND VGND VPWR VPWR sky130_fd_sc_hd__decap_8
XANTENNA_fanout255_X _4829_/C VGND VGND VPWR VPWR sky130_fd_sc_hd__diode_2
XTAP_TAPCELL_ROW_63_970 VGND VPWR sky130_fd_sc_hd__tapvpwrvgnd_1
X_5989_ clkload7/A _5989_/D fanout286/X VGND VGND VPWR VPWR _5989_/Q sky130_fd_sc_hd__dfrtp_1
XANTENNA__3229__S _3229_/S VGND VGND VPWR VPWR sky130_fd_sc_hd__diode_2
XFILLER_4_515 VGND VGND VPWR VPWR sky130_fd_sc_hd__decap_6
XFILLER_21_54 VGND VGND VPWR VPWR sky130_fd_sc_hd__fill_2
XFILLER_21_65 VGND VGND VPWR VPWR sky130_fd_sc_hd__decap_6
XANTENNA__3381__B1 _4544_/A VGND VGND VPWR VPWR sky130_fd_sc_hd__diode_2
XANTENNA__3920__A2 _3240_/B VGND VGND VPWR VPWR sky130_fd_sc_hd__diode_2
XANTENNA_fanout70_X _5109_/S VGND VGND VPWR VPWR sky130_fd_sc_hd__diode_2
XFILLER_35_419 VPWR VGND VPWR VGND sky130_ef_sc_hd__decap_12
XFILLER_46_51 VGND VGND VPWR VPWR sky130_fd_sc_hd__fill_2
XANTENNA__4633__B1 _4632_/X VGND VGND VPWR VPWR sky130_fd_sc_hd__diode_2
XFILLER_62_83 VGND VGND VPWR VPWR sky130_fd_sc_hd__fill_1
XTAP_TAPCELL_ROW_13_344 VGND VPWR sky130_fd_sc_hd__tapvpwrvgnd_1
XTAP_TAPCELL_ROW_41_697 VGND VPWR sky130_fd_sc_hd__tapvpwrvgnd_1
Xhold309 _5837_/Q VGND VGND VPWR VPWR hold309/X sky130_fd_sc_hd__dlygate4sd3_1
X_3340_ _6174_/Q _6032_/Q VGND VGND VPWR VPWR _3354_/D sky130_fd_sc_hd__xor2_1
XANTENNA__5113__A1 _3651_/B VGND VGND VPWR VPWR sky130_fd_sc_hd__diode_2
X_5010_ _4621_/X _5024_/A2 _5024_/B1 _4925_/X VGND VGND VPWR VPWR _5010_/X sky130_fd_sc_hd__a22o_1
X_3271_ _5397_/A _6026_/Q VGND VGND VPWR VPWR _3354_/A sky130_fd_sc_hd__and2b_1
XFILLER_78_360 VGND VGND VPWR VPWR sky130_fd_sc_hd__decap_4
XFILLER_23_3 VPWR VGND VPWR VGND sky130_ef_sc_hd__decap_12
XTAP_TAPCELL_ROW_49_797 VGND VPWR sky130_fd_sc_hd__tapvpwrvgnd_1
X_5912_ _6142_/CLK _5912_/D fanout326/X VGND VGND VPWR VPWR _5912_/Q sky130_fd_sc_hd__dfrtp_1
X_5843_ _6094_/CLK _5843_/D fanout350/X VGND VGND VPWR VPWR _5843_/Q sky130_fd_sc_hd__dfrtp_1
XANTENNA__2742__A _4404_/A VGND VGND VPWR VPWR sky130_fd_sc_hd__diode_2
XFILLER_21_113 VPWR VGND VPWR VGND sky130_ef_sc_hd__decap_12
X_5774_ _5792_/CLK _5774_/D fanout291/X VGND VGND VPWR VPWR _5774_/Q sky130_fd_sc_hd__dfrtp_1
X_2986_ _4977_/A _4232_/S VGND VGND VPWR VPWR _3127_/B sky130_fd_sc_hd__and2_2
X_4725_ _5764_/Q _5964_/Q _4751_/S VGND VGND VPWR VPWR _4725_/X sky130_fd_sc_hd__mux2_1
X_4656_ _4652_/X _4654_/X _4655_/X _4688_/B2 _4720_/C1 VGND VGND VPWR VPWR _4656_/X
+ sky130_fd_sc_hd__a221o_1
X_4587_ _4667_/B1 _4586_/X _4740_/B1 VGND VGND VPWR VPWR _4587_/X sky130_fd_sc_hd__a21o_1
X_3607_ _3607_/A _3712_/B _3713_/C _3607_/D VGND VGND VPWR VPWR _3617_/B sky130_fd_sc_hd__or4_1
XFILLER_1_507 VGND VGND VPWR VPWR sky130_fd_sc_hd__decap_3
X_3538_ _3538_/A _3538_/B VGND VGND VPWR VPWR _3538_/Y sky130_fd_sc_hd__xnor2_1
XANTENNA_clkbuf_leaf_51_clk_A clkload0/A VGND VGND VPWR VPWR sky130_fd_sc_hd__diode_2
XANTENNA__5104__A1 _5406_/A VGND VGND VPWR VPWR sky130_fd_sc_hd__diode_2
XANTENNA__3292__B _5447_/A VGND VGND VPWR VPWR sky130_fd_sc_hd__diode_2
X_3469_ _5247_/A _5210_/A VGND VGND VPWR VPWR _3475_/A sky130_fd_sc_hd__nor2_1
XANTENNA__4863__A0 _4970_/A0 VGND VGND VPWR VPWR sky130_fd_sc_hd__diode_2
X_5208_ _6131_/D _6130_/D _6129_/D _6128_/D VGND VGND VPWR VPWR _5237_/B sky130_fd_sc_hd__and4b_1
XFILLER_57_544 VGND VGND VPWR VPWR sky130_fd_sc_hd__fill_1
X_5139_ _4561_/A _4978_/C _4175_/D VGND VGND VPWR VPWR _6062_/D sky130_fd_sc_hd__o21ai_1
XTAP_TAPCELL_ROW_67_1017 VGND VPWR sky130_fd_sc_hd__tapvpwrvgnd_1
XFILLER_25_430 VPWR VGND VPWR VGND sky130_ef_sc_hd__decap_12
XANTENNA__3969__A2 _3426_/D VGND VGND VPWR VPWR sky130_fd_sc_hd__diode_2
XFILLER_37_290 VPWR VGND VPWR VGND sky130_ef_sc_hd__decap_12
XANTENNA__3748__A _5066_/S VGND VGND VPWR VPWR sky130_fd_sc_hd__diode_2
XTAP_TAPCELL_ROW_10_303 VGND VPWR sky130_fd_sc_hd__tapvpwrvgnd_1
XANTENNA__5736__Q _5736_/Q VGND VGND VPWR VPWR sky130_fd_sc_hd__diode_2
XTAP_TAPCELL_ROW_78_1157 VGND VPWR sky130_fd_sc_hd__tapvpwrvgnd_1
XPHY_EDGE_ROW_26_Left_107 VGND VGND VPWR VPWR sky130_fd_sc_hd__decap_3
XFILLER_79_113 VGND VGND VPWR VPWR sky130_fd_sc_hd__fill_2
XANTENNA_clkbuf_leaf_19_clk_A clkbuf_leaf_9_clk/A VGND VGND VPWR VPWR sky130_fd_sc_hd__diode_2
XANTENNA__5471__Q _5471_/Q VGND VGND VPWR VPWR sky130_fd_sc_hd__diode_2
XANTENNA__4854__A0 _5472_/Q VGND VGND VPWR VPWR sky130_fd_sc_hd__diode_2
XFILLER_63_503 VGND VGND VPWR VPWR sky130_fd_sc_hd__fill_1
XANTENNA__2880__A2 _2786_/X VGND VGND VPWR VPWR sky130_fd_sc_hd__diode_2
XTAP_TAPCELL_ROW_18_403 VGND VPWR sky130_fd_sc_hd__tapvpwrvgnd_1
XPHY_EDGE_ROW_35_Left_116 VGND VGND VPWR VPWR sky130_fd_sc_hd__decap_3
XFILLER_16_441 VPWR VGND VPWR VGND sky130_ef_sc_hd__decap_12
XFILLER_35_249 VPWR VGND VPWR VGND sky130_ef_sc_hd__decap_12
XTAP_TAPCELL_ROW_46_756 VGND VPWR sky130_fd_sc_hd__tapvpwrvgnd_1
XFILLER_73_93 VGND VGND VPWR VPWR sky130_fd_sc_hd__decap_8
X_2840_ _6128_/Q _2908_/B _2839_/X _2821_/X VGND VGND VPWR VPWR _6128_/D sky130_fd_sc_hd__a22o_2
XFILLER_31_477 VGND VGND VPWR VPWR sky130_fd_sc_hd__fill_1
X_2771_ _5722_/Q _5723_/Q VGND VGND VPWR VPWR _4315_/A sky130_fd_sc_hd__nand2b_2
XFILLER_31_488 VGND VGND VPWR VPWR sky130_fd_sc_hd__fill_2
X_5490_ _6021_/CLK _5490_/D fanout332/X VGND VGND VPWR VPWR _5490_/Q sky130_fd_sc_hd__dfrtp_4
X_4510_ _4496_/A _4521_/B _4509_/Y _4499_/A VGND VGND VPWR VPWR _4510_/X sky130_fd_sc_hd__a31o_1
Xhold117 _5705_/Q VGND VGND VPWR VPWR hold117/X sky130_fd_sc_hd__dlygate4sd3_1
X_4441_ _4447_/A _4439_/B _4430_/X VGND VGND VPWR VPWR _4442_/B sky130_fd_sc_hd__a21oi_1
Xhold106 _5807_/Q VGND VGND VPWR VPWR hold106/X sky130_fd_sc_hd__dlygate4sd3_1
XPHY_EDGE_ROW_44_Left_125 VGND VGND VPWR VPWR sky130_fd_sc_hd__decap_3
Xhold128 _6065_/Q VGND VGND VPWR VPWR hold128/X sky130_fd_sc_hd__dlygate4sd3_1
XPHY_EDGE_ROW_9_Right_9 VGND VGND VPWR VPWR sky130_fd_sc_hd__decap_3
Xhold139 _5857_/Q VGND VGND VPWR VPWR hold139/X sky130_fd_sc_hd__dlygate4sd3_1
X_4372_ _4357_/X _4371_/X _4359_/Y VGND VGND VPWR VPWR _5737_/D sky130_fd_sc_hd__o21ai_1
X_6111_ _6111_/CLK _6111_/D fanout335/X VGND VGND VPWR VPWR _6111_/Q sky130_fd_sc_hd__dfrtp_1
X_3323_ _5989_/Q _6175_/Q VGND VGND VPWR VPWR _3362_/D sky130_fd_sc_hd__and2b_1
XANTENNA__4845__A0 _5491_/Q VGND VGND VPWR VPWR sky130_fd_sc_hd__diode_2
X_6042_ _6106_/CLK _6042_/D fanout274/X VGND VGND VPWR VPWR _6042_/Q sky130_fd_sc_hd__dfrtp_1
X_3254_ _3254_/A VGND VGND VPWR VPWR _3268_/B sky130_fd_sc_hd__inv_2
XFILLER_66_363 VGND VGND VPWR VPWR sky130_fd_sc_hd__fill_1
XFILLER_66_341 VGND VGND VPWR VPWR sky130_fd_sc_hd__decap_6
XPHY_EDGE_ROW_53_Left_134 VGND VGND VPWR VPWR sky130_fd_sc_hd__decap_3
X_3185_ _3426_/A _3443_/C VGND VGND VPWR VPWR _4083_/B sky130_fd_sc_hd__or2_1
XANTENNA__2743__Y _4428_/A VGND VGND VPWR VPWR sky130_fd_sc_hd__diode_2
XFILLER_22_433 VPWR VGND VPWR VGND sky130_ef_sc_hd__decap_12
XFILLER_34_293 VGND VGND VPWR VPWR sky130_fd_sc_hd__decap_6
XANTENNA_fanout332_A fanout334/X VGND VGND VPWR VPWR sky130_fd_sc_hd__diode_2
X_5826_ _6021_/CLK _5826_/D fanout333/X VGND VGND VPWR VPWR _5826_/Q sky130_fd_sc_hd__dfrtp_1
XANTENNA__5022__B1 _5038_/B1 VGND VGND VPWR VPWR sky130_fd_sc_hd__diode_2
XFILLER_22_477 VGND VGND VPWR VPWR sky130_fd_sc_hd__decap_6
XANTENNA__3287__B _3905_/A VGND VGND VPWR VPWR sky130_fd_sc_hd__diode_2
X_2969_ _3129_/B _2980_/A _2977_/A VGND VGND VPWR VPWR _3153_/B sky130_fd_sc_hd__nand3b_2
XFILLER_10_628 VGND VGND VPWR VPWR sky130_fd_sc_hd__decap_3
X_5757_ _6111_/CLK _5757_/D fanout328/X VGND VGND VPWR VPWR _5757_/Q sky130_fd_sc_hd__dfrtp_1
XPHY_EDGE_ROW_62_Left_143 VGND VGND VPWR VPWR sky130_fd_sc_hd__decap_3
XANTENNA_fanout120_X _5096_/S VGND VGND VPWR VPWR sky130_fd_sc_hd__diode_2
XFILLER_5_109 VGND VGND VPWR VPWR sky130_fd_sc_hd__fill_1
X_4708_ _5962_/Q _5109_/S _4243_/S _4707_/X VGND VGND VPWR VPWR _4708_/X sky130_fd_sc_hd__a211o_1
X_5688_ _5690_/CLK _5688_/D fanout317/X VGND VGND VPWR VPWR _5688_/Q sky130_fd_sc_hd__dfrtp_1
XANTENNA__4399__A _4399_/A VGND VGND VPWR VPWR sky130_fd_sc_hd__diode_2
X_4639_ _5920_/Q _5761_/Q _4687_/S VGND VGND VPWR VPWR _4639_/X sky130_fd_sc_hd__mux2_1
XFILLER_76_105 VGND VGND VPWR VPWR sky130_fd_sc_hd__decap_4
XTAP_TAPCELL_ROW_73_1098 VGND VPWR sky130_fd_sc_hd__tapvpwrvgnd_1
XTAP_TAPCELL_ROW_73_1087 VGND VPWR sky130_fd_sc_hd__tapvpwrvgnd_1
XPHY_EDGE_ROW_71_Left_152 VGND VGND VPWR VPWR sky130_fd_sc_hd__decap_3
XANTENNA__4836__A0 _5520_/Q VGND VGND VPWR VPWR sky130_fd_sc_hd__diode_2
XANTENNA_fanout78_A _4828_/B2 VGND VGND VPWR VPWR sky130_fd_sc_hd__diode_2
XFILLER_57_363 VGND VGND VPWR VPWR sky130_fd_sc_hd__fill_2
XFILLER_45_525 VGND VGND VPWR VPWR sky130_fd_sc_hd__decap_6
XFILLER_17_249 VGND VGND VPWR VPWR sky130_fd_sc_hd__decap_3
XFILLER_33_709 VGND VGND VPWR VPWR sky130_fd_sc_hd__decap_4
XTAP_TAPCELL_ROW_43_715 VGND VPWR sky130_fd_sc_hd__tapvpwrvgnd_1
XANTENNA__3749__Y _4176_/C VGND VGND VPWR VPWR sky130_fd_sc_hd__diode_2
XANTENNA__5169__S _5170_/S VGND VGND VPWR VPWR sky130_fd_sc_hd__diode_2
XFILLER_13_433 VPWR VGND VPWR VGND sky130_ef_sc_hd__decap_12
XPHY_EDGE_ROW_80_Left_161 VGND VGND VPWR VPWR sky130_fd_sc_hd__decap_3
XANTENNA__3024__C1 _2977_/Y VGND VGND VPWR VPWR sky130_fd_sc_hd__diode_2
XTAP_TAPCELL_ROW_23_472 VGND VPWR sky130_fd_sc_hd__tapvpwrvgnd_1
XFILLER_40_296 VGND VGND VPWR VPWR sky130_fd_sc_hd__decap_3
XANTENNA__4801__S _4805_/S VGND VGND VPWR VPWR sky130_fd_sc_hd__diode_2
XFILLER_4_197 VGND VGND VPWR VPWR sky130_fd_sc_hd__decap_6
XFILLER_68_82 VGND VGND VPWR VPWR sky130_fd_sc_hd__fill_2
XANTENNA__4827__B1 _3254_/A VGND VGND VPWR VPWR sky130_fd_sc_hd__diode_2
XFILLER_48_352 VGND VGND VPWR VPWR sky130_fd_sc_hd__decap_4
X_4990_ _4220_/X _5038_/A2 _5038_/B1 _4895_/X VGND VGND VPWR VPWR _4990_/X sky130_fd_sc_hd__a22o_1
X_3941_ _5599_/Q hold478/X _2948_/Y _3918_/X VGND VGND VPWR VPWR _5599_/D sky130_fd_sc_hd__a31o_1
XANTENNA__5004__B1 _5024_/B1 VGND VGND VPWR VPWR sky130_fd_sc_hd__diode_2
X_3872_ _4108_/B _4108_/C _3773_/A VGND VGND VPWR VPWR _3872_/Y sky130_fd_sc_hd__a21oi_1
X_2823_ _2834_/C _2844_/D _2844_/C VGND VGND VPWR VPWR _2823_/Y sky130_fd_sc_hd__nand3b_2
X_5611_ _5635_/CLK _5611_/D fanout315/X VGND VGND VPWR VPWR _5611_/Q sky130_fd_sc_hd__dfrtp_1
XFILLER_31_274 VGND VGND VPWR VPWR sky130_fd_sc_hd__decap_6
XANTENNA__4711__S _4735_/S VGND VGND VPWR VPWR sky130_fd_sc_hd__diode_2
X_2754_ _6171_/Q VGND VGND VPWR VPWR _3298_/A sky130_fd_sc_hd__inv_2
X_5542_ _5697_/CLK _5542_/D VGND VGND VPWR VPWR hold34/A sky130_fd_sc_hd__dfxtp_1
X_5473_ _6021_/CLK _5473_/D fanout332/X VGND VGND VPWR VPWR _5473_/Q sky130_fd_sc_hd__dfrtp_4
X_4424_ _4424_/A _4424_/B VGND VGND VPWR VPWR _4447_/C sky130_fd_sc_hd__and2_1
X_4355_ _4354_/X _4353_/Y _4386_/S VGND VGND VPWR VPWR _4355_/X sky130_fd_sc_hd__mux2_1
XFILLER_59_606 VGND VGND VPWR VPWR sky130_fd_sc_hd__fill_1
X_3306_ _5201_/B _5987_/Q VGND VGND VPWR VPWR _3364_/C sky130_fd_sc_hd__and2b_1
X_4286_ _5705_/Q _4285_/X _4310_/S VGND VGND VPWR VPWR _4286_/X sky130_fd_sc_hd__mux2_1
XANTENNA__3570__B _3639_/A VGND VGND VPWR VPWR sky130_fd_sc_hd__diode_2
XFILLER_73_108 VGND VGND VPWR VPWR sky130_fd_sc_hd__fill_1
X_3237_ _5641_/Q hold39/X _3238_/S VGND VGND VPWR VPWR _5501_/D sky130_fd_sc_hd__mux2_1
XANTENNA_fanout282_A fanout283/X VGND VGND VPWR VPWR sky130_fd_sc_hd__diode_2
X_6025_ clkload4/A _6025_/D fanout281/X VGND VGND VPWR VPWR _6025_/Q sky130_fd_sc_hd__dfrtp_1
X_3168_ _5908_/Q _2987_/Y _3166_/X _3167_/X _2989_/Y VGND VGND VPWR VPWR _3168_/X
+ sky130_fd_sc_hd__o221a_1
XFILLER_39_374 VPWR VGND VPWR VGND sky130_ef_sc_hd__decap_12
XFILLER_64_29 VGND VGND VPWR VPWR sky130_fd_sc_hd__decap_4
XTAP_TAPCELL_ROW_1_189 VGND VPWR sky130_fd_sc_hd__tapvpwrvgnd_1
X_3099_ _5681_/Q _3095_/B _3098_/Y VGND VGND VPWR VPWR _5681_/D sky130_fd_sc_hd__o21a_1
Xfanout12 _5116_/S VGND VGND VPWR VPWR _5122_/S sky130_fd_sc_hd__clkbuf_4
Xfanout56 _4174_/X VGND VGND VPWR VPWR _4686_/B1 sky130_fd_sc_hd__buf_2
Xfanout23 _5186_/S VGND VGND VPWR VPWR _5185_/S sky130_fd_sc_hd__clkbuf_4
Xfanout34 _3725_/Y VGND VGND VPWR VPWR _4865_/A sky130_fd_sc_hd__buf_2
Xfanout45 _4740_/B1 VGND VGND VPWR VPWR _4684_/B1 sky130_fd_sc_hd__clkbuf_4
Xfanout67 _4737_/A2 VGND VGND VPWR VPWR _4753_/A2 sky130_fd_sc_hd__clkbuf_2
Xfanout89 _5350_/X VGND VGND VPWR VPWR _5376_/B sky130_fd_sc_hd__buf_1
X_5809_ _6026_/CLK _5809_/D fanout278/X VGND VGND VPWR VPWR _5809_/Q sky130_fd_sc_hd__dfrtp_1
Xfanout78 _4828_/B2 VGND VGND VPWR VPWR _4561_/B sky130_fd_sc_hd__buf_2
XFILLER_10_458 VGND VGND VPWR VPWR sky130_fd_sc_hd__fill_1
XTAP_TAPCELL_ROW_20_431 VGND VPWR sky130_fd_sc_hd__tapvpwrvgnd_1
XTAP_TAPCELL_ROW_75_1116 VGND VPWR sky130_fd_sc_hd__tapvpwrvgnd_1
XFILLER_1_134 VGND VGND VPWR VPWR sky130_fd_sc_hd__decap_6
XFILLER_2_657 VPWR VGND VPWR VGND sky130_ef_sc_hd__decap_12
Xhold470 _5682_/Q VGND VGND VPWR VPWR hold470/X sky130_fd_sc_hd__dlygate4sd3_1
XTAP_TAPCELL_ROW_9_289 VGND VPWR sky130_fd_sc_hd__tapvpwrvgnd_1
XANTENNA__4809__A0 _4970_/A0 VGND VGND VPWR VPWR sky130_fd_sc_hd__diode_2
XTAP_TAPCELL_ROW_28_531 VGND VPWR sky130_fd_sc_hd__tapvpwrvgnd_1
XFILLER_73_675 VGND VGND VPWR VPWR sky130_fd_sc_hd__fill_1
XFILLER_72_141 VPWR VGND VPWR VGND sky130_ef_sc_hd__decap_12
XTAP_TAPCELL_ROW_56_884 VGND VPWR sky130_fd_sc_hd__tapvpwrvgnd_1
XFILLER_60_369 VGND VGND VPWR VPWR sky130_fd_sc_hd__fill_1
XANTENNA__5200__B _5377_/A VGND VGND VPWR VPWR sky130_fd_sc_hd__diode_2
XFILLER_9_234 VGND VGND VPWR VPWR sky130_fd_sc_hd__fill_1
XFILLER_70_83 VGND VGND VPWR VPWR sky130_fd_sc_hd__fill_1
Xclkload26 _5965_/CLK VGND VGND VPWR VPWR clkload26/Y sky130_fd_sc_hd__inv_12
Xclkload15 _6032_/CLK VGND VGND VPWR VPWR clkload15/Y sky130_fd_sc_hd__clkinvlp_4
Xclkload48 _6092_/CLK VGND VGND VPWR VPWR clkload48/Y sky130_fd_sc_hd__clkinv_2
Xclkload37 _6149_/CLK VGND VGND VPWR VPWR clkload37/X sky130_fd_sc_hd__clkbuf_8
XANTENNA__4318__A1_N _4331_/A1 VGND VGND VPWR VPWR sky130_fd_sc_hd__diode_2
X_4140_ _4164_/B _4139_/B _4164_/A VGND VGND VPWR VPWR _4141_/B sky130_fd_sc_hd__a21o_1
X_4071_ _3967_/A _4070_/X _4069_/X _4542_/A VGND VGND VPWR VPWR _4071_/X sky130_fd_sc_hd__a211o_1
X_3022_ _5958_/Q _2971_/X _2973_/X _5966_/Q _2968_/X VGND VGND VPWR VPWR _3022_/X
+ sky130_fd_sc_hd__a221o_1
XANTENNA__4706__S _4746_/S VGND VGND VPWR VPWR sky130_fd_sc_hd__diode_2
XFILLER_36_344 VGND VGND VPWR VPWR sky130_fd_sc_hd__fill_1
XFILLER_63_141 VGND VGND VPWR VPWR sky130_fd_sc_hd__decap_8
XANTENNA__5225__B1 _6128_/D VGND VGND VPWR VPWR sky130_fd_sc_hd__diode_2
XFILLER_24_528 VGND VGND VPWR VPWR sky130_fd_sc_hd__decap_4
XFILLER_36_377 VPWR VGND VPWR VGND sky130_ef_sc_hd__decap_12
X_4973_ _4973_/A0 _4746_/X _4973_/S VGND VGND VPWR VPWR _4973_/X sky130_fd_sc_hd__mux2_1
XANTENNA__4579__A2 _4684_/A2 VGND VGND VPWR VPWR sky130_fd_sc_hd__diode_2
X_3924_ _5587_/Q _2955_/Y _3541_/Y _3918_/X VGND VGND VPWR VPWR _5587_/D sky130_fd_sc_hd__a22o_1
XFILLER_20_712 VGND VGND VPWR VPWR sky130_fd_sc_hd__fill_1
Xclkload9 clkload9/A VGND VGND VPWR VPWR clkload9/Y sky130_fd_sc_hd__inv_16
X_3855_ _5810_/Q _5511_/Q _3879_/S VGND VGND VPWR VPWR _3855_/X sky130_fd_sc_hd__mux2_1
X_2806_ _5891_/Q _2917_/A2 _2886_/B _5895_/Q VGND VGND VPWR VPWR _2806_/X sky130_fd_sc_hd__a22o_1
XANTENNA_fanout128_A _4877_/X VGND VGND VPWR VPWR sky130_fd_sc_hd__diode_2
XANTENNA__4736__C1 _3877_/S VGND VGND VPWR VPWR sky130_fd_sc_hd__diode_2
X_3786_ _5569_/Q _3785_/C _5570_/Q VGND VGND VPWR VPWR _3786_/Y sky130_fd_sc_hd__a21oi_1
X_5525_ _5635_/CLK hold42/X VGND VGND VPWR VPWR hold41/A sky130_fd_sc_hd__dfxtp_1
X_2737_ _5466_/Q VGND VGND VPWR VPWR _4083_/A sky130_fd_sc_hd__inv_2
X_5456_ _5453_/X _5454_/X _5455_/Y VGND VGND VPWR VPWR _5456_/X sky130_fd_sc_hd__o21a_1
X_4407_ _4408_/A _4408_/C _4404_/A VGND VGND VPWR VPWR _4407_/Y sky130_fd_sc_hd__a21oi_1
Xfanout202 _6113_/Q VGND VGND VPWR VPWR _2925_/D sky130_fd_sc_hd__buf_1
X_5387_ _5387_/A _5387_/B VGND VGND VPWR VPWR _5387_/Y sky130_fd_sc_hd__nand2_1
Xfanout213 _6048_/Q VGND VGND VPWR VPWR _3130_/A sky130_fd_sc_hd__clkbuf_2
X_4338_ _5734_/Q _4338_/B _4338_/C _4338_/D VGND VGND VPWR VPWR _4340_/B sky130_fd_sc_hd__and4_1
XFILLER_59_447 VGND VGND VPWR VPWR sky130_fd_sc_hd__fill_1
XTAP_TAPCELL_ROW_6_259 VGND VPWR sky130_fd_sc_hd__tapvpwrvgnd_1
Xfanout235 _5748_/Q VGND VGND VPWR VPWR _3647_/A sky130_fd_sc_hd__buf_2
Xfanout246 _4427_/A VGND VGND VPWR VPWR _4447_/A sky130_fd_sc_hd__buf_2
Xfanout224 _5755_/Q VGND VGND VPWR VPWR _2831_/B sky130_fd_sc_hd__dlymetal6s2s_1
XANTENNA_input2_A ui_in[7] VGND VGND VPWR VPWR sky130_fd_sc_hd__diode_2
Xfanout268 _5478_/Q VGND VGND VPWR VPWR _4973_/A0 sky130_fd_sc_hd__clkbuf_4
Xfanout257 _5727_/Q VGND VGND VPWR VPWR _5094_/A1 sky130_fd_sc_hd__clkbuf_4
XTAP_TAPCELL_ROW_70_1057 VGND VPWR sky130_fd_sc_hd__tapvpwrvgnd_1
X_4269_ _5567_/Q _5575_/Q _4277_/S VGND VGND VPWR VPWR _4270_/A sky130_fd_sc_hd__mux2_1
XANTENNA__6116__RESET_B fanout313/X VGND VGND VPWR VPWR sky130_fd_sc_hd__diode_2
Xfanout279 fanout287/X VGND VGND VPWR VPWR fanout279/X sky130_fd_sc_hd__clkbuf_2
X_6008_ _6088_/CLK _6008_/D fanout338/X VGND VGND VPWR VPWR _6008_/Q sky130_fd_sc_hd__dfrtp_1
XFILLER_54_141 VGND VGND VPWR VPWR sky130_fd_sc_hd__decap_3
XFILLER_54_174 VGND VGND VPWR VPWR sky130_fd_sc_hd__fill_1
XFILLER_42_336 VGND VGND VPWR VPWR sky130_fd_sc_hd__fill_1
XTAP_TAPCELL_ROW_53_843 VGND VPWR sky130_fd_sc_hd__tapvpwrvgnd_1
XFILLER_11_712 VGND VGND VPWR VPWR sky130_fd_sc_hd__fill_1
XANTENNA__4990__A2 _5038_/A2 VGND VGND VPWR VPWR sky130_fd_sc_hd__diode_2
XFILLER_6_204 VPWR VGND VPWR VGND sky130_ef_sc_hd__decap_12
XANTENNA__2810__D _2895_/A VGND VGND VPWR VPWR sky130_fd_sc_hd__diode_2
XFILLER_2_421 VPWR VGND VPWR VGND sky130_ef_sc_hd__decap_12
XFILLER_49_51 VGND VGND VPWR VPWR sky130_fd_sc_hd__decap_4
XFILLER_77_277 VGND VGND VPWR VPWR sky130_fd_sc_hd__fill_1
XFILLER_37_108 VGND VGND VPWR VPWR sky130_fd_sc_hd__decap_4
XFILLER_1_69 VPWR VGND VPWR VGND sky130_ef_sc_hd__decap_12
XFILLER_80_409 VGND VGND VPWR VPWR sky130_fd_sc_hd__decap_4
XFILLER_65_61 VGND VGND VPWR VPWR sky130_fd_sc_hd__fill_1
XFILLER_18_377 VPWR VGND VPWR VGND sky130_ef_sc_hd__decap_12
XANTENNA__3430__S _3434_/S VGND VGND VPWR VPWR sky130_fd_sc_hd__diode_2
XFILLER_33_325 VGND VGND VPWR VPWR sky130_fd_sc_hd__decap_6
XFILLER_21_509 VGND VGND VPWR VPWR sky130_fd_sc_hd__fill_1
XANTENNA__4718__C1 _4750_/C1 VGND VGND VPWR VPWR sky130_fd_sc_hd__diode_2
X_3640_ _4427_/A _6037_/Q VGND VGND VPWR VPWR _3660_/C sky130_fd_sc_hd__xor2_1
X_3571_ _6102_/Q _4452_/A VGND VGND VPWR VPWR _3674_/A sky130_fd_sc_hd__and2_1
XFILLER_53_3 VGND VGND VPWR VPWR sky130_fd_sc_hd__fill_2
X_5310_ _5310_/A _5318_/A VGND VGND VPWR VPWR _5310_/Y sky130_fd_sc_hd__nor2_1
XANTENNA__3941__B1 _3918_/X VGND VGND VPWR VPWR sky130_fd_sc_hd__diode_2
XANTENNA__5092__S _5097_/S VGND VGND VPWR VPWR sky130_fd_sc_hd__diode_2
X_5241_ _5256_/B _5256_/C VGND VGND VPWR VPWR _5342_/B sky130_fd_sc_hd__nand2_1
X_5172_ hold229/X _5478_/Q _5172_/S VGND VGND VPWR VPWR _6094_/D sky130_fd_sc_hd__mux2_1
X_4123_ _3772_/A _3772_/B _5569_/Q VGND VGND VPWR VPWR _4124_/D sky130_fd_sc_hd__a21oi_1
Xinput2 ui_in[7] VGND VGND VPWR VPWR input2/X sky130_fd_sc_hd__clkbuf_1
XTAP_TAPCELL_ROW_3_218 VGND VPWR sky130_fd_sc_hd__tapvpwrvgnd_1
X_4054_ _5664_/Q _4541_/S _3976_/A VGND VGND VPWR VPWR _4054_/X sky130_fd_sc_hd__a21o_1
X_3005_ hold242/X _3004_/X _3114_/S VGND VGND VPWR VPWR _6118_/D sky130_fd_sc_hd__mux2_1
XFILLER_36_163 VGND VGND VPWR VPWR sky130_fd_sc_hd__fill_1
XFILLER_51_177 VGND VGND VPWR VPWR sky130_fd_sc_hd__fill_2
XTAP_TAPCELL_ROW_50_802 VGND VPWR sky130_fd_sc_hd__tapvpwrvgnd_1
X_4956_ _4703_/X _4878_/A _4878_/B _4955_/X VGND VGND VPWR VPWR _4956_/X sky130_fd_sc_hd__a22o_1
X_4887_ _4196_/X _4878_/A _4878_/B _4886_/X VGND VGND VPWR VPWR _4887_/X sky130_fd_sc_hd__a22o_1
X_3907_ _3907_/A _3907_/B VGND VGND VPWR VPWR _3907_/X sky130_fd_sc_hd__and2_1
X_3838_ _5574_/Q _3826_/S _3837_/X VGND VGND VPWR VPWR _5574_/D sky130_fd_sc_hd__o21ba_1
XANTENNA__4724__A2 _4740_/A2 VGND VGND VPWR VPWR sky130_fd_sc_hd__diode_2
X_5508_ _6026_/CLK _5508_/D fanout277/X VGND VGND VPWR VPWR _5508_/Q sky130_fd_sc_hd__dfrtp_1
X_3769_ _5803_/Q _5504_/Q _3904_/S VGND VGND VPWR VPWR _3769_/X sky130_fd_sc_hd__mux2_1
XANTENNA_fanout200_X _2864_/A VGND VGND VPWR VPWR sky130_fd_sc_hd__diode_2
X_5439_ _5435_/Y _5437_/Y _5438_/X _5366_/A VGND VGND VPWR VPWR _5439_/X sky130_fd_sc_hd__a211o_1
XANTENNA__3742__C _4865_/A VGND VGND VPWR VPWR sky130_fd_sc_hd__diode_2
XANTENNA__3160__A1 _5491_/Q VGND VGND VPWR VPWR sky130_fd_sc_hd__diode_2
XFILLER_59_288 VGND VGND VPWR VPWR sky130_fd_sc_hd__fill_1
XTAP_TAPCELL_ROW_58_902 VGND VPWR sky130_fd_sc_hd__tapvpwrvgnd_1
XFILLER_19_43 VGND VGND VPWR VPWR sky130_fd_sc_hd__fill_1
XANTENNA_fanout60_A _5055_/S VGND VGND VPWR VPWR sky130_fd_sc_hd__diode_2
XANTENNA__5739__Q _5739_/Q VGND VGND VPWR VPWR sky130_fd_sc_hd__diode_2
XFILLER_35_75 VGND VGND VPWR VPWR sky130_fd_sc_hd__fill_1
XFILLER_35_97 VGND VGND VPWR VPWR sky130_fd_sc_hd__decap_6
XFILLER_23_391 VGND VGND VPWR VPWR sky130_fd_sc_hd__fill_1
XFILLER_7_502 VGND VGND VPWR VPWR sky130_fd_sc_hd__fill_2
XANTENNA__5474__Q _5474_/Q VGND VGND VPWR VPWR sky130_fd_sc_hd__diode_2
XANTENNA__4715__A2 _4747_/A2 VGND VGND VPWR VPWR sky130_fd_sc_hd__diode_2
XANTENNA__3923__B1 _3544_/X VGND VGND VPWR VPWR sky130_fd_sc_hd__diode_2
XFILLER_2_251 VGND VGND VPWR VPWR sky130_fd_sc_hd__fill_1
XFILLER_78_531 VGND VGND VPWR VPWR sky130_fd_sc_hd__fill_1
XFILLER_76_60 VGND VGND VPWR VPWR sky130_fd_sc_hd__fill_2
XFILLER_65_236 VPWR VGND VPWR VGND sky130_ef_sc_hd__decap_12
XTAP_TAPCELL_ROW_36_629 VGND VPWR sky130_fd_sc_hd__tapvpwrvgnd_1
X_4810_ _4973_/A0 hold282/X _4810_/S VGND VGND VPWR VPWR _5847_/D sky130_fd_sc_hd__mux2_1
X_5790_ _5792_/CLK _5790_/D fanout291/X VGND VGND VPWR VPWR _5790_/Q sky130_fd_sc_hd__dfrtp_1
XTAP_TAPCELL_ROW_16_375 VGND VPWR sky130_fd_sc_hd__tapvpwrvgnd_1
X_4741_ _5766_/Q _5966_/Q _4751_/S VGND VGND VPWR VPWR _4741_/X sky130_fd_sc_hd__mux2_1
XTAP_TAPCELL_ROW_16_386 VGND VPWR sky130_fd_sc_hd__tapvpwrvgnd_1
XFILLER_21_339 VPWR VGND VPWR VGND sky130_ef_sc_hd__decap_12
XANTENNA__3396__A _3396_/A VGND VGND VPWR VPWR sky130_fd_sc_hd__diode_2
X_4672_ _4672_/A1 _4671_/X _4670_/X _4704_/C1 VGND VGND VPWR VPWR _4672_/X sky130_fd_sc_hd__a211o_1
X_3623_ _3623_/A _5973_/Q VGND VGND VPWR VPWR _3623_/Y sky130_fd_sc_hd__xnor2_1
X_3554_ _3552_/Y _3553_/X _3551_/X VGND VGND VPWR VPWR _3554_/Y sky130_fd_sc_hd__o21ai_4
X_3485_ _5211_/A VGND VGND VPWR VPWR _3487_/B sky130_fd_sc_hd__inv_2
XFILLER_69_520 VGND VGND VPWR VPWR sky130_fd_sc_hd__fill_1
X_5224_ _5230_/A _3491_/B _5206_/B _3663_/A VGND VGND VPWR VPWR _5231_/B sky130_fd_sc_hd__o31a_1
X_5155_ hold199/X _5493_/Q _5167_/S VGND VGND VPWR VPWR _6077_/D sky130_fd_sc_hd__mux2_1
XANTENNA_fanout195_A _5369_/A VGND VGND VPWR VPWR sky130_fd_sc_hd__diode_2
X_5086_ hold157/X _5469_/Q _5098_/S VGND VGND VPWR VPWR _6009_/D sky130_fd_sc_hd__mux2_1
X_4106_ _5579_/Q _4106_/B _4106_/C VGND VGND VPWR VPWR _4106_/X sky130_fd_sc_hd__and3_1
X_4037_ hold114/X _3975_/Y _4035_/X _4036_/X VGND VGND VPWR VPWR _5660_/D sky130_fd_sc_hd__a22o_1
XFILLER_71_217 VGND VGND VPWR VPWR sky130_fd_sc_hd__fill_1
XTAP_TAPCELL_ROW_63_971 VGND VPWR sky130_fd_sc_hd__tapvpwrvgnd_1
X_5988_ _6110_/CLK _5988_/D fanout299/X VGND VGND VPWR VPWR _5988_/Q sky130_fd_sc_hd__dfrtp_1
X_4939_ hold459/X _4948_/A2 _4938_/X VGND VGND VPWR VPWR _5922_/D sky130_fd_sc_hd__a21o_1
XANTENNA__4945__A2 _4951_/A2 VGND VGND VPWR VPWR sky130_fd_sc_hd__diode_2
XFILLER_20_372 VPWR VGND VPWR VGND sky130_ef_sc_hd__decap_12
XFILLER_21_11 VGND VGND VPWR VPWR sky130_fd_sc_hd__decap_3
XANTENNA__4865__A _4865_/A VGND VGND VPWR VPWR sky130_fd_sc_hd__diode_2
XANTENNA__2892__B1 _2918_/B1 VGND VGND VPWR VPWR sky130_fd_sc_hd__diode_2
XANTENNA__4881__B2 _4880_/X VGND VGND VPWR VPWR sky130_fd_sc_hd__diode_2
XANTENNA_fanout63_X _3905_/B VGND VGND VPWR VPWR sky130_fd_sc_hd__diode_2
XFILLER_28_450 VGND VGND VPWR VPWR sky130_fd_sc_hd__fill_1
XFILLER_46_85 VGND VGND VPWR VPWR sky130_fd_sc_hd__decap_6
XANTENNA__5469__Q _5469_/Q VGND VGND VPWR VPWR sky130_fd_sc_hd__diode_2
XFILLER_15_133 VGND VGND VPWR VPWR sky130_fd_sc_hd__decap_6
XFILLER_15_144 VPWR VGND VPWR VGND sky130_ef_sc_hd__decap_12
XFILLER_43_420 VGND VGND VPWR VPWR sky130_fd_sc_hd__decap_8
XANTENNA__4804__S _4810_/S VGND VGND VPWR VPWR sky130_fd_sc_hd__diode_2
XANTENNA__4936__A2 _4951_/A2 VGND VGND VPWR VPWR sky130_fd_sc_hd__diode_2
XFILLER_11_350 VGND VGND VPWR VPWR sky130_fd_sc_hd__decap_8
XTAP_TAPCELL_ROW_13_345 VGND VPWR sky130_fd_sc_hd__tapvpwrvgnd_1
XTAP_TAPCELL_ROW_41_687 VGND VPWR sky130_fd_sc_hd__tapvpwrvgnd_1
XTAP_TAPCELL_ROW_41_698 VGND VPWR sky130_fd_sc_hd__tapvpwrvgnd_1
XFILLER_7_68 VGND VGND VPWR VPWR sky130_fd_sc_hd__fill_1
X_3270_ _5201_/B _3270_/B VGND VGND VPWR VPWR _3356_/A sky130_fd_sc_hd__nor2_1
XFILLER_16_3 VGND VGND VPWR VPWR sky130_fd_sc_hd__fill_2
X_5911_ _5952_/CLK _5911_/D fanout330/X VGND VGND VPWR VPWR _5911_/Q sky130_fd_sc_hd__dfrtp_1
XTAP_TAPCELL_ROW_49_798 VGND VPWR sky130_fd_sc_hd__tapvpwrvgnd_1
XTAP_TAPCELL_ROW_49_787 VGND VPWR sky130_fd_sc_hd__tapvpwrvgnd_1
X_5842_ _6021_/CLK _5842_/D fanout333/X VGND VGND VPWR VPWR _5842_/Q sky130_fd_sc_hd__dfrtp_1
XANTENNA__4714__S _4746_/S VGND VGND VPWR VPWR sky130_fd_sc_hd__diode_2
X_5773_ _5942_/CLK _5773_/D fanout296/X VGND VGND VPWR VPWR _5773_/Q sky130_fd_sc_hd__dfrtp_1
XANTENNA__4927__A2 _4951_/A2 VGND VGND VPWR VPWR sky130_fd_sc_hd__diode_2
XTAP_TAPCELL_ROW_60_930 VGND VPWR sky130_fd_sc_hd__tapvpwrvgnd_1
XFILLER_22_637 VGND VGND VPWR VPWR sky130_fd_sc_hd__decap_3
X_2985_ _5919_/Q _2978_/Y _2982_/X _2975_/X VGND VGND VPWR VPWR _2985_/Y sky130_fd_sc_hd__o22ai_1
X_4724_ _5964_/Q _4740_/A2 _4243_/S _4723_/X VGND VGND VPWR VPWR _4724_/X sky130_fd_sc_hd__a211o_1
XFILLER_21_147 VGND VGND VPWR VPWR sky130_fd_sc_hd__fill_1
X_4655_ _5922_/Q _5763_/Q _4687_/S VGND VGND VPWR VPWR _4655_/X sky130_fd_sc_hd__mux2_1
X_4586_ _5490_/Q _5796_/Q _4610_/S VGND VGND VPWR VPWR _4586_/X sky130_fd_sc_hd__mux2_1
X_3606_ _3656_/A _6057_/Q VGND VGND VPWR VPWR _3607_/D sky130_fd_sc_hd__and2_1
XANTENNA_fanout110_A _4864_/S VGND VGND VPWR VPWR sky130_fd_sc_hd__diode_2
XANTENNA__3573__B _3623_/A VGND VGND VPWR VPWR sky130_fd_sc_hd__diode_2
X_3537_ _3537_/A _3538_/B VGND VGND VPWR VPWR _3562_/C sky130_fd_sc_hd__nand2_1
XANTENNA__4560__B1 _4829_/B VGND VGND VPWR VPWR sky130_fd_sc_hd__diode_2
X_3468_ _6160_/Q _3468_/B _3468_/C _3468_/D VGND VGND VPWR VPWR _5210_/A sky130_fd_sc_hd__or4_1
X_3399_ _5900_/Q _4866_/S _3399_/C VGND VGND VPWR VPWR _3407_/S sky130_fd_sc_hd__nand3b_4
X_5207_ _5207_/A _5207_/B VGND VGND VPWR VPWR _5228_/A sky130_fd_sc_hd__and2_1
X_5138_ _6061_/Q _5750_/Q _5138_/S VGND VGND VPWR VPWR _6061_/D sky130_fd_sc_hd__mux2_1
XFILLER_29_225 VGND VGND VPWR VPWR sky130_fd_sc_hd__decap_8
XANTENNA__4615__A1 _5766_/Q VGND VGND VPWR VPWR sky130_fd_sc_hd__diode_2
XTAP_TAPCELL_ROW_67_1018 VGND VPWR sky130_fd_sc_hd__tapvpwrvgnd_1
X_5069_ hold268/X _5518_/Q _5097_/S VGND VGND VPWR VPWR _5992_/D sky130_fd_sc_hd__mux2_1
XFILLER_25_442 VGND VGND VPWR VPWR sky130_fd_sc_hd__decap_6
XFILLER_13_604 VGND VGND VPWR VPWR sky130_fd_sc_hd__decap_6
XTAP_TAPCELL_ROW_10_304 VGND VPWR sky130_fd_sc_hd__tapvpwrvgnd_1
XTAP_TAPCELL_ROW_78_1158 VGND VPWR sky130_fd_sc_hd__tapvpwrvgnd_1
XANTENNA__4606__A1 _5765_/Q VGND VGND VPWR VPWR sky130_fd_sc_hd__diode_2
XTAP_TAPCELL_ROW_18_404 VGND VPWR sky130_fd_sc_hd__tapvpwrvgnd_1
XFILLER_35_217 VGND VGND VPWR VPWR sky130_fd_sc_hd__fill_1
XTAP_TAPCELL_ROW_46_757 VGND VPWR sky130_fd_sc_hd__tapvpwrvgnd_1
XANTENNA__4082__A2 _3240_/B VGND VGND VPWR VPWR sky130_fd_sc_hd__diode_2
XFILLER_16_453 VGND VGND VPWR VPWR sky130_fd_sc_hd__fill_1
XFILLER_43_261 VGND VGND VPWR VPWR sky130_fd_sc_hd__decap_4
XANTENNA__4909__A2 _4951_/A2 VGND VGND VPWR VPWR sky130_fd_sc_hd__diode_2
X_2770_ _5722_/Q _5723_/Q VGND VGND VPWR VPWR _4247_/B sky130_fd_sc_hd__and2b_1
XFILLER_12_681 VGND VGND VPWR VPWR sky130_fd_sc_hd__decap_3
XANTENNA__4790__A0 _5490_/Q VGND VGND VPWR VPWR sky130_fd_sc_hd__diode_2
XFILLER_7_140 VGND VGND VPWR VPWR sky130_fd_sc_hd__fill_1
X_4440_ _4440_/A _4440_/B VGND VGND VPWR VPWR _4442_/A sky130_fd_sc_hd__nor2_1
Xhold107 _5856_/Q VGND VGND VPWR VPWR hold107/X sky130_fd_sc_hd__dlygate4sd3_1
Xhold129 _6018_/Q VGND VGND VPWR VPWR hold129/X sky130_fd_sc_hd__dlygate4sd3_1
Xhold118 _6079_/Q VGND VGND VPWR VPWR hold118/X sky130_fd_sc_hd__dlygate4sd3_1
X_4371_ _4367_/X _4370_/X _4386_/S VGND VGND VPWR VPWR _4371_/X sky130_fd_sc_hd__mux2_1
X_6110_ _6110_/CLK _6110_/D fanout325/X VGND VGND VPWR VPWR _6110_/Q sky130_fd_sc_hd__dfrtp_1
XANTENNA__5098__A1 _5477_/Q VGND VGND VPWR VPWR sky130_fd_sc_hd__diode_2
X_3322_ _6165_/Q _5979_/Q VGND VGND VPWR VPWR _3365_/D sky130_fd_sc_hd__and2b_1
XFILLER_58_309 VGND VGND VPWR VPWR sky130_fd_sc_hd__fill_1
X_6041_ _6061_/CLK _6041_/D fanout275/X VGND VGND VPWR VPWR _6041_/Q sky130_fd_sc_hd__dfrtp_1
X_3253_ _3517_/B _3550_/A _5203_/A VGND VGND VPWR VPWR _3254_/A sky130_fd_sc_hd__or3_4
XFILLER_39_501 VGND VGND VPWR VPWR sky130_fd_sc_hd__decap_3
XANTENNA__4709__S _4735_/S VGND VGND VPWR VPWR sky130_fd_sc_hd__diode_2
X_3184_ _5599_/Q _3426_/D VGND VGND VPWR VPWR _3443_/C sky130_fd_sc_hd__nand2_1
XFILLER_66_353 VGND VGND VPWR VPWR sky130_fd_sc_hd__decap_8
XANTENNA__2753__A _6167_/Q VGND VGND VPWR VPWR sky130_fd_sc_hd__diode_2
X_5825_ _6092_/CLK _5825_/D fanout339/X VGND VGND VPWR VPWR _5825_/Q sky130_fd_sc_hd__dfrtp_1
X_2968_ _6048_/Q _6047_/Q _2977_/A VGND VGND VPWR VPWR _2968_/X sky130_fd_sc_hd__and3b_2
X_5756_ _6111_/CLK _5756_/D fanout328/X VGND VGND VPWR VPWR _5756_/Q sky130_fd_sc_hd__dfrtp_1
X_4707_ _5929_/Q _5066_/S _4747_/B1 _4706_/X VGND VGND VPWR VPWR _4707_/X sky130_fd_sc_hd__a22o_1
X_5687_ _5690_/CLK _5687_/D fanout317/X VGND VGND VPWR VPWR _5687_/Q sky130_fd_sc_hd__dfstp_1
X_2899_ _2896_/X _2898_/X _2785_/X VGND VGND VPWR VPWR _2901_/C sky130_fd_sc_hd__o21a_1
X_4638_ _4750_/A1 _4637_/X _4636_/X _4750_/C1 VGND VGND VPWR VPWR _4638_/X sky130_fd_sc_hd__o211a_1
X_4569_ hold260/X _4745_/A2 _4568_/X VGND VGND VPWR VPWR _5769_/D sky130_fd_sc_hd__o21a_1
XFILLER_1_305 VPWR VGND VPWR VGND sky130_ef_sc_hd__decap_12
XANTENNA__5089__A1 _5472_/Q VGND VGND VPWR VPWR sky130_fd_sc_hd__diode_2
XTAP_TAPCELL_ROW_73_1088 VGND VPWR sky130_fd_sc_hd__tapvpwrvgnd_1
XFILLER_76_139 VGND VGND VPWR VPWR sky130_fd_sc_hd__fill_1
XTAP_TAPCELL_ROW_43_716 VGND VPWR sky130_fd_sc_hd__tapvpwrvgnd_1
XFILLER_9_405 VGND VGND VPWR VPWR sky130_fd_sc_hd__decap_6
XFILLER_13_445 VGND VGND VPWR VPWR sky130_fd_sc_hd__decap_3
XFILLER_40_231 VGND VGND VPWR VPWR sky130_fd_sc_hd__fill_1
XFILLER_40_253 VPWR VGND VPWR VGND sky130_ef_sc_hd__decap_12
XANTENNA_fanout26_X _4226_/S VGND VGND VPWR VPWR sky130_fd_sc_hd__diode_2
XFILLER_9_449 VPWR VGND VPWR VGND sky130_ef_sc_hd__decap_12
XTAP_TAPCELL_ROW_23_462 VGND VPWR sky130_fd_sc_hd__tapvpwrvgnd_1
XTAP_TAPCELL_ROW_23_473 VGND VPWR sky130_fd_sc_hd__tapvpwrvgnd_1
XFILLER_4_154 VGND VGND VPWR VPWR sky130_fd_sc_hd__fill_1
XANTENNA__4877__X _4877_/X VGND VGND VPWR VPWR sky130_fd_sc_hd__diode_2
XFILLER_4_47 VGND VGND VPWR VPWR sky130_fd_sc_hd__fill_1
XANTENNA__3433__S _3434_/S VGND VGND VPWR VPWR sky130_fd_sc_hd__diode_2
XANTENNA__4827__B2 _4870_/A1 VGND VGND VPWR VPWR sky130_fd_sc_hd__diode_2
XFILLER_0_393 VPWR VGND VPWR VGND sky130_ef_sc_hd__decap_12
XFILLER_75_150 VGND VGND VPWR VPWR sky130_fd_sc_hd__decap_6
X_3940_ _5598_/Q _3564_/A _3940_/S VGND VGND VPWR VPWR _5598_/D sky130_fd_sc_hd__mux2_1
X_3871_ _5577_/Q _3883_/C VGND VGND VPWR VPWR _3895_/C sky130_fd_sc_hd__and2_1
XANTENNA_clkbuf_leaf_50_clk_A clkload0/A VGND VGND VPWR VPWR sky130_fd_sc_hd__diode_2
X_2822_ _5718_/Q _5067_/B VGND VGND VPWR VPWR _2908_/B sky130_fd_sc_hd__nand2_1
X_5610_ _5635_/CLK _5610_/D fanout311/X VGND VGND VPWR VPWR _5610_/Q sky130_fd_sc_hd__dfrtp_1
X_2753_ _6167_/Q VGND VGND VPWR VPWR _3336_/A sky130_fd_sc_hd__inv_2
X_5541_ _5696_/CLK _5541_/D VGND VGND VPWR VPWR hold45/A sky130_fd_sc_hd__dfxtp_1
X_5472_ _6144_/CLK _5472_/D fanout329/X VGND VGND VPWR VPWR _5472_/Q sky130_fd_sc_hd__dfrtp_4
X_4423_ _4424_/A _4424_/B VGND VGND VPWR VPWR _4423_/Y sky130_fd_sc_hd__nor2_1
X_4354_ _5736_/Q _4353_/A _4354_/S VGND VGND VPWR VPWR _4354_/X sky130_fd_sc_hd__mux2_1
XPHY_EDGE_ROW_18_Left_99 VGND VGND VPWR VPWR sky130_fd_sc_hd__decap_3
X_3305_ _5200_/C _3305_/B VGND VGND VPWR VPWR _3364_/B sky130_fd_sc_hd__nor2_1
X_4285_ _4209_/X _4284_/X _4291_/S VGND VGND VPWR VPWR _4285_/X sky130_fd_sc_hd__mux2_1
XFILLER_58_139 VGND VGND VPWR VPWR sky130_fd_sc_hd__fill_1
XANTENNA__4818__A1 _2744_/A VGND VGND VPWR VPWR sky130_fd_sc_hd__diode_2
X_6024_ clkload5/A _6024_/D fanout281/X VGND VGND VPWR VPWR _6024_/Q sky130_fd_sc_hd__dfrtp_1
X_3236_ _5640_/Q hold53/X _3238_/S VGND VGND VPWR VPWR _5500_/D sky130_fd_sc_hd__mux2_1
X_3167_ _5916_/Q _2988_/B _3127_/B VGND VGND VPWR VPWR _3167_/X sky130_fd_sc_hd__a21o_1
XFILLER_27_559 VGND VGND VPWR VPWR sky130_fd_sc_hd__fill_1
X_3098_ _4014_/A _3103_/C VGND VGND VPWR VPWR _3098_/Y sky130_fd_sc_hd__nor2_1
XFILLER_14_209 VPWR VGND VPWR VGND sky130_ef_sc_hd__decap_12
Xfanout13 _4544_/X VGND VGND VPWR VPWR _4823_/A2 sky130_fd_sc_hd__buf_2
XFILLER_23_710 VGND VGND VPWR VPWR sky130_fd_sc_hd__decap_3
XFILLER_80_29 VPWR VGND VPWR VGND sky130_ef_sc_hd__decap_12
XANTENNA_clkbuf_leaf_18_clk_A clkbuf_leaf_9_clk/A VGND VGND VPWR VPWR sky130_fd_sc_hd__diode_2
Xfanout46 _4166_/X VGND VGND VPWR VPWR _4740_/B1 sky130_fd_sc_hd__buf_2
Xfanout24 _5138_/S VGND VGND VPWR VPWR _5137_/S sky130_fd_sc_hd__clkbuf_4
Xfanout35 _3766_/Y VGND VGND VPWR VPWR _3767_/A sky130_fd_sc_hd__buf_4
XANTENNA_fanout230_X _4973_/S VGND VGND VPWR VPWR sky130_fd_sc_hd__diode_2
Xfanout68 _3368_/X VGND VGND VPWR VPWR _4737_/A2 sky130_fd_sc_hd__buf_2
X_5808_ _5811_/CLK _5808_/D fanout288/X VGND VGND VPWR VPWR _5808_/Q sky130_fd_sc_hd__dfrtp_1
Xfanout79 _3329_/X VGND VGND VPWR VPWR _4828_/B2 sky130_fd_sc_hd__clkbuf_2
Xfanout57 _5123_/B VGND VGND VPWR VPWR _5066_/S sky130_fd_sc_hd__buf_4
X_5739_ clkload9/A _5739_/D fanout282/X VGND VGND VPWR VPWR _5739_/Q sky130_fd_sc_hd__dfrtp_2
XTAP_TAPCELL_ROW_20_432 VGND VPWR sky130_fd_sc_hd__tapvpwrvgnd_1
XFILLER_13_67 VGND VGND VPWR VPWR sky130_fd_sc_hd__fill_1
XFILLER_6_419 VGND VGND VPWR VPWR sky130_fd_sc_hd__fill_1
XTAP_TAPCELL_ROW_75_1117 VGND VPWR sky130_fd_sc_hd__tapvpwrvgnd_1
Xhold460 _5967_/Q VGND VGND VPWR VPWR hold460/X sky130_fd_sc_hd__dlygate4sd3_1
XFILLER_1_113 VGND VGND VPWR VPWR sky130_fd_sc_hd__fill_1
Xhold471 _5594_/Q VGND VGND VPWR VPWR hold471/X sky130_fd_sc_hd__dlygate4sd3_1
XFILLER_2_669 VPWR VGND VPWR VGND sky130_ef_sc_hd__decap_12
XFILLER_73_610 VGND VGND VPWR VPWR sky130_fd_sc_hd__fill_1
XANTENNA__4873__A _4873_/A VGND VGND VPWR VPWR sky130_fd_sc_hd__diode_2
XTAP_TAPCELL_ROW_28_532 VGND VPWR sky130_fd_sc_hd__tapvpwrvgnd_1
XFILLER_72_153 VGND VGND VPWR VPWR sky130_fd_sc_hd__decap_6
XTAP_TAPCELL_ROW_56_874 VGND VPWR sky130_fd_sc_hd__tapvpwrvgnd_1
XANTENNA__2824__C _2824_/C VGND VGND VPWR VPWR sky130_fd_sc_hd__diode_2
XTAP_TAPCELL_ROW_56_885 VGND VPWR sky130_fd_sc_hd__tapvpwrvgnd_1
XFILLER_26_581 VGND VGND VPWR VPWR sky130_fd_sc_hd__decap_3
XANTENNA__5477__Q _5477_/Q VGND VGND VPWR VPWR sky130_fd_sc_hd__diode_2
XFILLER_54_85 VPWR VGND VPWR VGND sky130_ef_sc_hd__decap_12
XFILLER_13_242 VGND VGND VPWR VPWR sky130_fd_sc_hd__decap_8
XANTENNA__5200__C _5200_/C VGND VGND VPWR VPWR sky130_fd_sc_hd__diode_2
XFILLER_13_297 VPWR VGND VPWR VGND sky130_ef_sc_hd__decap_12
XANTENNA__3428__S _3434_/S VGND VGND VPWR VPWR sky130_fd_sc_hd__diode_2
Xclkload16 _6050_/CLK VGND VGND VPWR VPWR clkload16/Y sky130_fd_sc_hd__inv_6
Xclkload27 _6097_/CLK VGND VGND VPWR VPWR clkload27/Y sky130_fd_sc_hd__inv_12
Xclkload49 _6088_/CLK VGND VGND VPWR VPWR clkload49/Y sky130_fd_sc_hd__clkinv_4
Xclkload38 _6160_/CLK VGND VGND VPWR VPWR clkload38/Y sky130_fd_sc_hd__inv_12
XFILLER_5_441 VGND VGND VPWR VPWR sky130_fd_sc_hd__decap_6
XFILLER_5_485 VGND VGND VPWR VPWR sky130_fd_sc_hd__fill_1
X_4070_ hold21/A hold62/A _4070_/S VGND VGND VPWR VPWR _4070_/X sky130_fd_sc_hd__mux2_1
X_3021_ hold112/X _3020_/X _3114_/S VGND VGND VPWR VPWR _6122_/D sky130_fd_sc_hd__mux2_1
XFILLER_64_643 VGND VGND VPWR VPWR sky130_fd_sc_hd__fill_1
X_4972_ hold438/X _4972_/A2 _4971_/X VGND VGND VPWR VPWR _5933_/D sky130_fd_sc_hd__a21o_1
XFILLER_17_570 VGND VGND VPWR VPWR sky130_fd_sc_hd__decap_6
XANTENNA__4984__B1 _5038_/B1 VGND VGND VPWR VPWR sky130_fd_sc_hd__diode_2
X_3923_ _5586_/Q _3240_/B _3544_/X _3918_/X VGND VGND VPWR VPWR _5586_/D sky130_fd_sc_hd__a22o_1
XANTENNA__4722__S _4746_/S VGND VGND VPWR VPWR sky130_fd_sc_hd__diode_2
X_3854_ _5427_/A _3902_/A2 _3853_/X VGND VGND VPWR VPWR _3854_/X sky130_fd_sc_hd__o21a_1
X_2805_ _5879_/Q _2910_/B _2916_/B _5875_/Q VGND VGND VPWR VPWR _2805_/X sky130_fd_sc_hd__a22o_1
X_3785_ _5569_/Q _5570_/Q _3785_/C VGND VGND VPWR VPWR _3811_/C sky130_fd_sc_hd__and3_1
X_5524_ _6144_/CLK _5524_/D fanout331/X VGND VGND VPWR VPWR _5524_/Q sky130_fd_sc_hd__dfrtp_4
X_2736_ _5616_/Q VGND VGND VPWR VPWR _2949_/A sky130_fd_sc_hd__inv_2
X_5455_ _5453_/X _5454_/X _5366_/A VGND VGND VPWR VPWR _5455_/Y sky130_fd_sc_hd__a21oi_1
X_4406_ _3479_/X _4403_/Y _4420_/B _4405_/Y VGND VGND VPWR VPWR _4406_/X sky130_fd_sc_hd__a22o_1
Xfanout203 _2871_/C VGND VGND VPWR VPWR _2925_/B sky130_fd_sc_hd__buf_2
Xfanout214 _3128_/B VGND VGND VPWR VPWR _2980_/A sky130_fd_sc_hd__clkbuf_4
X_5386_ _5381_/A _5381_/B _5378_/A VGND VGND VPWR VPWR _5387_/B sky130_fd_sc_hd__a21o_1
X_4337_ _6177_/Q _4141_/B _4138_/A _4320_/A _4155_/A VGND VGND VPWR VPWR _4338_/D
+ sky130_fd_sc_hd__a2111o_1
XTAP_TAPCELL_ROW_6_249 VGND VPWR sky130_fd_sc_hd__tapvpwrvgnd_1
Xfanout236 _3639_/A VGND VGND VPWR VPWR _4522_/A sky130_fd_sc_hd__buf_2
Xfanout247 _5742_/Q VGND VGND VPWR VPWR _4427_/A sky130_fd_sc_hd__clkbuf_4
Xfanout225 _3900_/A VGND VGND VPWR VPWR _3887_/A sky130_fd_sc_hd__clkbuf_2
Xfanout258 _5726_/Q VGND VGND VPWR VPWR _2843_/B sky130_fd_sc_hd__clkbuf_4
Xfanout269 _5477_/Q VGND VGND VPWR VPWR _4970_/A0 sky130_fd_sc_hd__clkbuf_4
XTAP_TAPCELL_ROW_70_1058 VGND VPWR sky130_fd_sc_hd__tapvpwrvgnd_1
X_4268_ hold371/X _4267_/X _4312_/S VGND VGND VPWR VPWR _5710_/D sky130_fd_sc_hd__mux2_1
X_6007_ _6091_/CLK _6007_/D fanout347/X VGND VGND VPWR VPWR _6007_/Q sky130_fd_sc_hd__dfrtp_1
X_3219_ hold50/X _5642_/Q _3219_/S VGND VGND VPWR VPWR _5486_/D sky130_fd_sc_hd__mux2_1
XANTENNA__4672__C1 _4704_/C1 VGND VGND VPWR VPWR sky130_fd_sc_hd__diode_2
X_4199_ _4198_/X _4196_/X _4226_/S VGND VGND VPWR VPWR _4200_/B sky130_fd_sc_hd__mux2_1
XFILLER_27_323 VGND VGND VPWR VPWR sky130_fd_sc_hd__fill_1
XANTENNA__3227__A0 _4967_/A0 VGND VGND VPWR VPWR sky130_fd_sc_hd__diode_2
XTAP_TAPCELL_ROW_53_844 VGND VPWR sky130_fd_sc_hd__tapvpwrvgnd_1
XANTENNA__3778__A1 _4404_/A VGND VGND VPWR VPWR sky130_fd_sc_hd__diode_2
XANTENNA__4727__A0 _5764_/Q VGND VGND VPWR VPWR sky130_fd_sc_hd__diode_2
XTAP_TAPCELL_ROW_33_590 VGND VPWR sky130_fd_sc_hd__tapvpwrvgnd_1
XFILLER_10_245 VGND VGND VPWR VPWR sky130_fd_sc_hd__decap_6
XFILLER_6_216 VGND VGND VPWR VPWR sky130_fd_sc_hd__fill_1
XFILLER_2_433 VPWR VGND VPWR VGND sky130_ef_sc_hd__decap_12
XFILLER_77_223 VGND VGND VPWR VPWR sky130_fd_sc_hd__fill_1
Xhold290 _5779_/Q VGND VGND VPWR VPWR hold290/X sky130_fd_sc_hd__dlygate4sd3_1
XANTENNA__5760__Q _5760_/Q VGND VGND VPWR VPWR sky130_fd_sc_hd__diode_2
XFILLER_49_96 VGND VGND VPWR VPWR sky130_fd_sc_hd__decap_6
XFILLER_1_15 VPWR VGND VPWR VGND sky130_ef_sc_hd__decap_12
XFILLER_46_621 VGND VGND VPWR VPWR sky130_fd_sc_hd__fill_1
XFILLER_61_602 VGND VGND VPWR VPWR sky130_fd_sc_hd__fill_1
XFILLER_60_101 VPWR VGND VPWR VGND sky130_ef_sc_hd__decap_12
XFILLER_18_389 VPWR VGND VPWR VGND sky130_ef_sc_hd__decap_12
XFILLER_45_164 VGND VGND VPWR VPWR sky130_fd_sc_hd__fill_1
X_3570_ _6105_/Q _3639_/A VGND VGND VPWR VPWR _3576_/A sky130_fd_sc_hd__xor2_1
XANTENNA__3941__A1 _5599_/Q VGND VGND VPWR VPWR sky130_fd_sc_hd__diode_2
X_5240_ _4344_/D _5211_/A _4344_/A VGND VGND VPWR VPWR _5244_/A sky130_fd_sc_hd__a21o_1
XFILLER_46_3 VGND VGND VPWR VPWR sky130_fd_sc_hd__fill_2
X_5171_ hold247/X _5477_/Q _5172_/S VGND VGND VPWR VPWR _6093_/D sky130_fd_sc_hd__mux2_1
XPHY_EDGE_ROW_18_Right_18 VGND VGND VPWR VPWR sky130_fd_sc_hd__decap_3
X_4122_ _5580_/Q _3907_/X _3773_/B _5569_/Q VGND VGND VPWR VPWR _4126_/B sky130_fd_sc_hd__a2bb2o_1
XANTENNA__4717__S _4735_/S VGND VGND VPWR VPWR sky130_fd_sc_hd__diode_2
XTAP_TAPCELL_ROW_3_219 VGND VPWR sky130_fd_sc_hd__tapvpwrvgnd_1
X_4053_ _4074_/S1 _4052_/X _4051_/X _4542_/A VGND VGND VPWR VPWR _4053_/X sky130_fd_sc_hd__a211o_1
Xinput3 uio_in[2] VGND VGND VPWR VPWR input3/X sky130_fd_sc_hd__clkbuf_1
X_3004_ _3002_/X _3003_/X _3953_/B VGND VGND VPWR VPWR _3004_/X sky130_fd_sc_hd__mux2_1
XFILLER_52_613 VGND VGND VPWR VPWR sky130_fd_sc_hd__fill_1
X_4955_ _2843_/B _4698_/X _4973_/S VGND VGND VPWR VPWR _4955_/X sky130_fd_sc_hd__mux2_1
XPHY_EDGE_ROW_27_Right_27 VGND VGND VPWR VPWR sky130_fd_sc_hd__decap_3
XTAP_TAPCELL_ROW_50_803 VGND VPWR sky130_fd_sc_hd__tapvpwrvgnd_1
X_3906_ _3906_/A1 _3906_/A2 _3904_/X _3905_/X VGND VGND VPWR VPWR _3907_/B sky130_fd_sc_hd__a31oi_1
XANTENNA__3857__A _5427_/A VGND VGND VPWR VPWR sky130_fd_sc_hd__diode_2
XANTENNA_fanout140_A _5026_/A2 VGND VGND VPWR VPWR sky130_fd_sc_hd__diode_2
X_4886_ _5795_/Q _5519_/Q _4901_/S VGND VGND VPWR VPWR _4886_/X sky130_fd_sc_hd__mux2_1
XANTENNA_fanout238_A _3626_/A VGND VGND VPWR VPWR sky130_fd_sc_hd__diode_2
XANTENNA__4709__A0 _5762_/Q VGND VGND VPWR VPWR sky130_fd_sc_hd__diode_2
X_3837_ _3916_/S _3859_/C _3835_/Y _3836_/X _3826_/S VGND VGND VPWR VPWR _3837_/X
+ sky130_fd_sc_hd__o311a_1
XTAP_TAPCELL_ROW_30_560 VGND VPWR sky130_fd_sc_hd__tapvpwrvgnd_1
X_3768_ _3761_/X _3783_/A _3766_/Y _3372_/X VGND VGND VPWR VPWR _3772_/A sky130_fd_sc_hd__a22oi_1
X_2719_ _3887_/A VGND VGND VPWR VPWR _2719_/Y sky130_fd_sc_hd__inv_2
X_5507_ clkload4/A _5507_/D fanout278/X VGND VGND VPWR VPWR _5507_/Q sky130_fd_sc_hd__dfrtp_1
X_3699_ _4428_/A _6037_/Q _3638_/C _3645_/B _3653_/B VGND VGND VPWR VPWR _3721_/D
+ sky130_fd_sc_hd__a2111o_1
X_5438_ _5434_/X _5436_/Y _5428_/A _5431_/Y VGND VGND VPWR VPWR _5438_/X sky130_fd_sc_hd__o211a_1
XPHY_EDGE_ROW_36_Right_36 VGND VGND VPWR VPWR sky130_fd_sc_hd__decap_3
X_5369_ _5369_/A _5453_/B VGND VGND VPWR VPWR _5372_/B sky130_fd_sc_hd__nor2_1
XANTENNA__3160__A2 _5471_/Q VGND VGND VPWR VPWR sky130_fd_sc_hd__diode_2
XTAP_TAPCELL_ROW_58_903 VGND VPWR sky130_fd_sc_hd__tapvpwrvgnd_1
XFILLER_19_55 VGND VGND VPWR VPWR sky130_fd_sc_hd__fill_1
XFILLER_28_676 VGND VGND VPWR VPWR sky130_fd_sc_hd__fill_1
XANTENNA__4660__A2 _4748_/A2 VGND VGND VPWR VPWR sky130_fd_sc_hd__diode_2
XTAP_TAPCELL_ROW_38_660 VGND VPWR sky130_fd_sc_hd__tapvpwrvgnd_1
XPHY_EDGE_ROW_45_Right_45 VGND VGND VPWR VPWR sky130_fd_sc_hd__decap_3
XFILLER_15_337 VPWR VGND VPWR VGND sky130_ef_sc_hd__decap_12
XANTENNA__5901__RESET_B fanout292/X VGND VGND VPWR VPWR sky130_fd_sc_hd__diode_2
XFILLER_7_558 VGND VGND VPWR VPWR sky130_fd_sc_hd__fill_2
XPHY_EDGE_ROW_54_Right_54 VGND VGND VPWR VPWR sky130_fd_sc_hd__decap_3
XANTENNA__3923__B2 _3918_/X VGND VGND VPWR VPWR sky130_fd_sc_hd__diode_2
XANTENNA__5490__Q _5490_/Q VGND VGND VPWR VPWR sky130_fd_sc_hd__diode_2
XFILLER_76_83 VGND VGND VPWR VPWR sky130_fd_sc_hd__fill_1
XANTENNA__3441__S _3442_/S VGND VGND VPWR VPWR sky130_fd_sc_hd__diode_2
XFILLER_65_248 VGND VGND VPWR VPWR sky130_fd_sc_hd__decap_4
XPHY_EDGE_ROW_63_Right_63 VGND VGND VPWR VPWR sky130_fd_sc_hd__decap_3
XFILLER_18_131 VGND VGND VPWR VPWR sky130_fd_sc_hd__decap_3
XANTENNA__4651__A2 _4684_/A2 VGND VGND VPWR VPWR sky130_fd_sc_hd__diode_2
XFILLER_73_281 VGND VGND VPWR VPWR sky130_fd_sc_hd__fill_1
XFILLER_18_197 VGND VGND VPWR VPWR sky130_fd_sc_hd__decap_8
XANTENNA__4272__S _5458_/C VGND VGND VPWR VPWR sky130_fd_sc_hd__diode_2
X_4740_ _5966_/Q _4740_/A2 _4740_/B1 _4739_/X VGND VGND VPWR VPWR _4740_/X sky130_fd_sc_hd__a211o_1
XTAP_TAPCELL_ROW_16_376 VGND VPWR sky130_fd_sc_hd__tapvpwrvgnd_1
X_4671_ _5924_/Q _5765_/Q _4687_/S VGND VGND VPWR VPWR _4671_/X sky130_fd_sc_hd__mux2_1
XANTENNA__3396__B _4544_/A VGND VGND VPWR VPWR sky130_fd_sc_hd__diode_2
X_3622_ _4517_/A _5977_/Q VGND VGND VPWR VPWR _3718_/B sky130_fd_sc_hd__xor2_1
XPHY_EDGE_ROW_72_Right_72 VGND VGND VPWR VPWR sky130_fd_sc_hd__decap_3
X_3553_ _3519_/X _3550_/B _3521_/Y _3549_/A VGND VGND VPWR VPWR _3553_/X sky130_fd_sc_hd__a31o_1
X_3484_ _3530_/A _3486_/B _3488_/B VGND VGND VPWR VPWR _5211_/A sky130_fd_sc_hd__or3_2
X_5223_ _6127_/Q _5223_/B VGND VGND VPWR VPWR _6127_/D sky130_fd_sc_hd__and2_1
X_5154_ hold151/X _5492_/Q _5166_/S VGND VGND VPWR VPWR _6076_/D sky130_fd_sc_hd__mux2_1
X_4105_ _4106_/B _4106_/C _5579_/Q VGND VGND VPWR VPWR _4105_/Y sky130_fd_sc_hd__a21oi_1
X_5085_ hold166/X _5468_/Q _5096_/S VGND VGND VPWR VPWR _6008_/D sky130_fd_sc_hd__mux2_1
X_4036_ hold88/A _4541_/S _3976_/A VGND VGND VPWR VPWR _4036_/X sky130_fd_sc_hd__a21o_1
XFILLER_25_602 VGND VGND VPWR VPWR sky130_fd_sc_hd__fill_2
XFILLER_52_432 VGND VGND VPWR VPWR sky130_fd_sc_hd__fill_1
XTAP_TAPCELL_ROW_63_972 VGND VPWR sky130_fd_sc_hd__tapvpwrvgnd_1
XFILLER_52_487 VGND VGND VPWR VPWR sky130_fd_sc_hd__fill_2
XFILLER_12_307 VGND VGND VPWR VPWR sky130_fd_sc_hd__fill_1
X_5987_ clkload5/A _5987_/D fanout281/X VGND VGND VPWR VPWR _5987_/Q sky130_fd_sc_hd__dfrtp_1
X_4938_ _4655_/X _4950_/A2 _4950_/B1 _4937_/X VGND VGND VPWR VPWR _4938_/X sky130_fd_sc_hd__a22o_1
XANTENNA_fanout143_X _4878_/A VGND VGND VPWR VPWR sky130_fd_sc_hd__diode_2
X_4869_ _2720_/Y _4167_/B _5901_/Q VGND VGND VPWR VPWR _4869_/X sky130_fd_sc_hd__o21a_1
XANTENNA__4910__S _4943_/S VGND VGND VPWR VPWR sky130_fd_sc_hd__diode_2
XANTENNA_fanout310_X fanout310/X VGND VGND VPWR VPWR sky130_fd_sc_hd__diode_2
XFILLER_20_362 VGND VGND VPWR VPWR sky130_fd_sc_hd__fill_2
XFILLER_20_384 VPWR VGND VPWR VGND sky130_ef_sc_hd__decap_12
XANTENNA__3381__A2 _3396_/A VGND VGND VPWR VPWR sky130_fd_sc_hd__diode_2
XFILLER_0_701 VPWR VGND VPWR VGND sky130_ef_sc_hd__decap_12
XANTENNA_fanout56_X _4686_/B1 VGND VGND VPWR VPWR sky130_fd_sc_hd__diode_2
XPHY_EDGE_ROW_6_Left_87 VGND VGND VPWR VPWR sky130_fd_sc_hd__decap_3
XFILLER_15_156 VPWR VGND VPWR VGND sky130_ef_sc_hd__decap_12
XFILLER_62_41 VGND VGND VPWR VPWR sky130_fd_sc_hd__fill_1
XFILLER_62_85 VGND VGND VPWR VPWR sky130_fd_sc_hd__decap_6
XTAP_TAPCELL_ROW_13_346 VGND VPWR sky130_fd_sc_hd__tapvpwrvgnd_1
XFILLER_7_36 VGND VGND VPWR VPWR sky130_fd_sc_hd__fill_1
XTAP_TAPCELL_ROW_41_688 VGND VPWR sky130_fd_sc_hd__tapvpwrvgnd_1
XANTENNA__3436__S _3442_/S VGND VGND VPWR VPWR sky130_fd_sc_hd__diode_2
X_5910_ _5965_/CLK _5910_/D fanout302/X VGND VGND VPWR VPWR _5910_/Q sky130_fd_sc_hd__dfrtp_1
XTAP_TAPCELL_ROW_49_788 VGND VPWR sky130_fd_sc_hd__tapvpwrvgnd_1
XFILLER_34_421 VPWR VGND VPWR VGND sky130_ef_sc_hd__decap_12
XANTENNA__5098__S _5098_/S VGND VGND VPWR VPWR sky130_fd_sc_hd__diode_2
X_5841_ _6092_/CLK _5841_/D fanout340/X VGND VGND VPWR VPWR _5841_/Q sky130_fd_sc_hd__dfrtp_1
X_5772_ _5942_/CLK _5772_/D fanout296/X VGND VGND VPWR VPWR _5772_/Q sky130_fd_sc_hd__dfrtp_1
XTAP_TAPCELL_ROW_60_931 VGND VPWR sky130_fd_sc_hd__tapvpwrvgnd_1
X_2984_ _4977_/A _4623_/S VGND VGND VPWR VPWR _2984_/Y sky130_fd_sc_hd__nand2_1
XFILLER_34_498 VGND VGND VPWR VPWR sky130_fd_sc_hd__fill_1
X_4723_ _5931_/Q _5123_/B _4747_/B1 _4722_/X VGND VGND VPWR VPWR _4723_/X sky130_fd_sc_hd__a22o_1
XANTENNA__4730__S _4746_/S VGND VGND VPWR VPWR sky130_fd_sc_hd__diode_2
X_4654_ _4686_/A1 _4653_/X _4678_/C1 VGND VGND VPWR VPWR _4654_/X sky130_fd_sc_hd__o21a_1
X_4585_ hold253/X _4737_/A2 _4584_/X VGND VGND VPWR VPWR _5771_/D sky130_fd_sc_hd__o21a_1
X_3605_ _4464_/A _6056_/Q VGND VGND VPWR VPWR _3713_/C sky130_fd_sc_hd__nor2_1
XANTENNA_fanout103_A _5025_/A2 VGND VGND VPWR VPWR sky130_fd_sc_hd__diode_2
X_3536_ _3549_/A _3528_/X _3535_/Y _3534_/Y VGND VGND VPWR VPWR _3536_/Y sky130_fd_sc_hd__o31ai_4
X_3467_ _6158_/Q _6157_/Q _6159_/Q _3467_/D VGND VGND VPWR VPWR _3468_/D sky130_fd_sc_hd__or4_1
X_5206_ _5237_/A _5206_/B _5206_/C VGND VGND VPWR VPWR _5206_/Y sky130_fd_sc_hd__nor3_1
X_3398_ _5900_/Q _4866_/S VGND VGND VPWR VPWR _4867_/B sky130_fd_sc_hd__nand2b_1
X_5137_ hold329/X _4522_/C _5137_/S VGND VGND VPWR VPWR _6060_/D sky130_fd_sc_hd__mux2_1
XFILLER_29_215 VGND VGND VPWR VPWR sky130_fd_sc_hd__decap_4
X_5068_ hold109/X _5517_/Q _5097_/S VGND VGND VPWR VPWR _5991_/D sky130_fd_sc_hd__mux2_1
XTAP_TAPCELL_ROW_67_1019 VGND VPWR sky130_fd_sc_hd__tapvpwrvgnd_1
X_4019_ _5651_/Q _5652_/Q _4019_/C VGND VGND VPWR VPWR _4024_/C sky130_fd_sc_hd__and3_1
XPHY_EDGE_ROW_0_Right_0 VGND VGND VPWR VPWR sky130_fd_sc_hd__decap_3
XTAP_TAPCELL_ROW_10_305 VGND VPWR sky130_fd_sc_hd__tapvpwrvgnd_1
XFILLER_21_671 VGND VGND VPWR VPWR sky130_fd_sc_hd__fill_1
XTAP_TAPCELL_ROW_78_1159 VGND VPWR sky130_fd_sc_hd__tapvpwrvgnd_1
XFILLER_0_531 VGND VGND VPWR VPWR sky130_fd_sc_hd__fill_1
XFILLER_0_597 VGND VGND VPWR VPWR sky130_fd_sc_hd__decap_6
XFILLER_75_354 VPWR VGND VPWR VGND sky130_ef_sc_hd__decap_12
XTAP_TAPCELL_ROW_18_405 VGND VPWR sky130_fd_sc_hd__tapvpwrvgnd_1
XTAP_TAPCELL_ROW_46_758 VGND VPWR sky130_fd_sc_hd__tapvpwrvgnd_1
XFILLER_28_270 VGND VGND VPWR VPWR sky130_fd_sc_hd__decap_6
XANTENNA__2843__B _2843_/B VGND VGND VPWR VPWR sky130_fd_sc_hd__diode_2
XFILLER_43_295 VPWR VGND VPWR VGND sky130_ef_sc_hd__decap_12
XANTENNA__5031__A2 _5043_/A2 VGND VGND VPWR VPWR sky130_fd_sc_hd__diode_2
Xhold108 _5565_/Q VGND VGND VPWR VPWR hold108/X sky130_fd_sc_hd__dlygate4sd3_1
X_4370_ _4384_/B _4370_/B VGND VGND VPWR VPWR _4370_/X sky130_fd_sc_hd__or2_1
Xhold119 _5854_/Q VGND VGND VPWR VPWR hold119/X sky130_fd_sc_hd__dlygate4sd3_1
X_3321_ _5447_/A _5989_/Q VGND VGND VPWR VPWR _3360_/C sky130_fd_sc_hd__and2b_1
XANTENNA__3690__A _4399_/A VGND VGND VPWR VPWR sky130_fd_sc_hd__diode_2
X_6040_ _6106_/CLK _6040_/D fanout274/X VGND VGND VPWR VPWR _6040_/Q sky130_fd_sc_hd__dfrtp_1
XFILLER_3_391 VGND VGND VPWR VPWR sky130_fd_sc_hd__fill_1
X_3252_ _6125_/Q _3705_/A _4342_/A VGND VGND VPWR VPWR _3455_/B sky130_fd_sc_hd__or3_1
X_3183_ _5724_/Q _3183_/B VGND VGND VPWR VPWR _6195_/A sky130_fd_sc_hd__and2b_1
XFILLER_19_281 VGND VGND VPWR VPWR sky130_fd_sc_hd__fill_1
X_5824_ _6093_/CLK _5824_/D fanout345/X VGND VGND VPWR VPWR _5824_/Q sky130_fd_sc_hd__dfrtp_1
XANTENNA__5022__A2 _5038_/A2 VGND VGND VPWR VPWR sky130_fd_sc_hd__diode_2
X_2967_ _3130_/A _3128_/B VGND VGND VPWR VPWR _2967_/X sky130_fd_sc_hd__and2b_1
X_5755_ _6111_/CLK _5755_/D fanout328/X VGND VGND VPWR VPWR _5755_/Q sky130_fd_sc_hd__dfrtp_1
X_2898_ _6005_/Q _2910_/B _2917_/A2 _6017_/Q _2897_/X VGND VGND VPWR VPWR _2898_/X
+ sky130_fd_sc_hd__a221o_1
X_4706_ _5795_/Q _5727_/Q _4746_/S VGND VGND VPWR VPWR _4706_/X sky130_fd_sc_hd__mux2_1
XANTENNA_fanout318_A fanout324/X VGND VGND VPWR VPWR sky130_fd_sc_hd__diode_2
X_5686_ _5686_/CLK _5686_/D VGND VGND VPWR VPWR _5686_/Q sky130_fd_sc_hd__dfxtp_2
X_4637_ _5953_/Q _5761_/Q _4687_/S VGND VGND VPWR VPWR _4637_/X sky130_fd_sc_hd__mux2_1
XFILLER_78_29 VGND VGND VPWR VPWR sky130_fd_sc_hd__fill_1
X_4568_ _4672_/A1 _4567_/X _4566_/X _4704_/C1 VGND VGND VPWR VPWR _4568_/X sky130_fd_sc_hd__a211o_1
XFILLER_1_317 VGND VGND VPWR VPWR sky130_fd_sc_hd__decap_4
X_4499_ _4499_/A _4499_/B VGND VGND VPWR VPWR _4499_/Y sky130_fd_sc_hd__nand2_1
X_3519_ _3521_/B _3521_/C _3538_/A VGND VGND VPWR VPWR _3519_/X sky130_fd_sc_hd__a21o_1
XTAP_TAPCELL_ROW_73_1089 VGND VPWR sky130_fd_sc_hd__tapvpwrvgnd_1
X_6169_ clkload8/A _6169_/D fanout285/X VGND VGND VPWR VPWR _6169_/Q sky130_fd_sc_hd__dfrtp_1
XFILLER_69_192 VGND VGND VPWR VPWR sky130_fd_sc_hd__fill_1
XANTENNA__5246__C1 _5353_/B VGND VGND VPWR VPWR sky130_fd_sc_hd__diode_2
XFILLER_17_207 VGND VGND VPWR VPWR sky130_fd_sc_hd__fill_1
XANTENNA__2944__A _6131_/D VGND VGND VPWR VPWR sky130_fd_sc_hd__diode_2
XTAP_TAPCELL_ROW_43_717 VGND VPWR sky130_fd_sc_hd__tapvpwrvgnd_1
XFILLER_13_413 VGND VGND VPWR VPWR sky130_fd_sc_hd__fill_1
XANTENNA__5013__A2 _5025_/A2 VGND VGND VPWR VPWR sky130_fd_sc_hd__diode_2
XFILLER_43_65 VGND VGND VPWR VPWR sky130_fd_sc_hd__fill_1
XFILLER_9_439 VGND VGND VPWR VPWR sky130_fd_sc_hd__decap_8
XTAP_TAPCELL_ROW_23_463 VGND VPWR sky130_fd_sc_hd__tapvpwrvgnd_1
XFILLER_40_265 VGND VGND VPWR VPWR sky130_fd_sc_hd__fill_1
Xclkbuf_leaf_20_clk clkbuf_leaf_9_clk/A VGND VGND VPWR VPWR _6097_/CLK sky130_fd_sc_hd__clkbuf_8
XANTENNA__5763__Q _5763_/Q VGND VGND VPWR VPWR sky130_fd_sc_hd__diode_2
XFILLER_4_15 VGND VGND VPWR VPWR sky130_fd_sc_hd__decap_3
XFILLER_4_26 VGND VGND VPWR VPWR sky130_fd_sc_hd__fill_2
XANTENNA__4827__A2 _2964_/B VGND VGND VPWR VPWR sky130_fd_sc_hd__diode_2
XANTENNA__2838__A1 _5517_/Q VGND VGND VPWR VPWR sky130_fd_sc_hd__diode_2
XFILLER_48_365 VGND VGND VPWR VPWR sky130_fd_sc_hd__fill_2
XANTENNA__3669__B _4464_/A VGND VGND VPWR VPWR sky130_fd_sc_hd__diode_2
XPHY_EDGE_ROW_9_Left_90 VGND VGND VPWR VPWR sky130_fd_sc_hd__decap_3
XANTENNA__5004__A2 _5024_/A2 VGND VGND VPWR VPWR sky130_fd_sc_hd__diode_2
X_3870_ _3906_/A1 _3906_/A2 _3868_/X _3869_/X VGND VGND VPWR VPWR _4108_/C sky130_fd_sc_hd__a31oi_2
X_2821_ _2784_/X _2815_/X _2820_/X VGND VGND VPWR VPWR _2821_/X sky130_fd_sc_hd__a21o_1
XFILLER_76_3 VGND VGND VPWR VPWR sky130_fd_sc_hd__fill_2
Xclkbuf_leaf_11_clk clkbuf_leaf_9_clk/A VGND VGND VPWR VPWR _5792_/CLK sky130_fd_sc_hd__clkbuf_8
X_5540_ _5645_/CLK _5540_/D VGND VGND VPWR VPWR hold32/A sky130_fd_sc_hd__dfxtp_1
X_2752_ _5980_/Q VGND VGND VPWR VPWR _3305_/B sky130_fd_sc_hd__inv_2
X_5471_ _6144_/CLK _5471_/D fanout331/X VGND VGND VPWR VPWR _5471_/Q sky130_fd_sc_hd__dfrtp_4
X_4422_ _4444_/C _4421_/Y _4436_/S _4419_/Y VGND VGND VPWR VPWR _4422_/X sky130_fd_sc_hd__a211o_1
X_4353_ _4353_/A VGND VGND VPWR VPWR _4353_/Y sky130_fd_sc_hd__inv_2
X_4284_ _5717_/Q _4308_/A2 _4250_/Y _4283_/X VGND VGND VPWR VPWR _4284_/X sky130_fd_sc_hd__a22o_1
XANTENNA__5405__A _5406_/A VGND VGND VPWR VPWR sky130_fd_sc_hd__diode_2
X_3304_ _5987_/Q _5201_/B VGND VGND VPWR VPWR _3362_/B sky130_fd_sc_hd__and2b_1
X_3235_ _5639_/Q hold40/X _3238_/S VGND VGND VPWR VPWR _5499_/D sky130_fd_sc_hd__mux2_1
X_6023_ clkload5/A _6023_/D fanout281/X VGND VGND VPWR VPWR _6023_/Q sky130_fd_sc_hd__dfrtp_1
XANTENNA__2829__A1 _5471_/Q VGND VGND VPWR VPWR sky130_fd_sc_hd__diode_2
X_3166_ _5924_/Q _2978_/Y _3164_/X _3165_/X VGND VGND VPWR VPWR _3166_/X sky130_fd_sc_hd__o22a_1
XANTENNA_fanout170_A _2964_/B VGND VGND VPWR VPWR sky130_fd_sc_hd__diode_2
X_3097_ _5680_/Q _5681_/Q _3097_/C VGND VGND VPWR VPWR _3103_/C sky130_fd_sc_hd__and3_1
XANTENNA_fanout268_A _5478_/Q VGND VGND VPWR VPWR sky130_fd_sc_hd__diode_2
Xfanout47 _4704_/C1 VGND VGND VPWR VPWR _4720_/C1 sky130_fd_sc_hd__clkbuf_4
Xfanout36 _3725_/C VGND VGND VPWR VPWR _4762_/C sky130_fd_sc_hd__buf_2
Xfanout25 _5051_/S VGND VGND VPWR VPWR _5054_/S sky130_fd_sc_hd__clkbuf_4
Xfanout14 _4544_/X VGND VGND VPWR VPWR _4824_/A2 sky130_fd_sc_hd__dlymetal6s2s_1
XFILLER_10_405 VGND VGND VPWR VPWR sky130_fd_sc_hd__fill_2
X_3999_ hold385/X _5636_/Q _4005_/S VGND VGND VPWR VPWR _5635_/D sky130_fd_sc_hd__mux2_1
X_5807_ clkload4/A _5807_/D fanout277/X VGND VGND VPWR VPWR _5807_/Q sky130_fd_sc_hd__dfrtp_1
Xfanout69 _5109_/S VGND VGND VPWR VPWR _5127_/B sky130_fd_sc_hd__clkbuf_4
Xfanout58 _5055_/S VGND VGND VPWR VPWR _5123_/B sky130_fd_sc_hd__buf_2
XFILLER_13_46 VGND VGND VPWR VPWR sky130_fd_sc_hd__fill_1
X_5738_ clkload8/A _5738_/D fanout285/X VGND VGND VPWR VPWR _5738_/Q sky130_fd_sc_hd__dfrtp_1
XANTENNA__4754__A1 _5793_/Q VGND VGND VPWR VPWR sky130_fd_sc_hd__diode_2
XANTENNA__4754__B2 _3549_/Y VGND VGND VPWR VPWR sky130_fd_sc_hd__diode_2
XTAP_TAPCELL_ROW_20_433 VGND VPWR sky130_fd_sc_hd__tapvpwrvgnd_1
X_5669_ _5682_/CLK _5669_/D VGND VGND VPWR VPWR _5669_/Q sky130_fd_sc_hd__dfxtp_1
XTAP_TAPCELL_ROW_75_1118 VGND VPWR sky130_fd_sc_hd__tapvpwrvgnd_1
Xhold461 _5931_/Q VGND VGND VPWR VPWR hold461/X sky130_fd_sc_hd__dlygate4sd3_1
XANTENNA__2939__A _5490_/Q VGND VGND VPWR VPWR sky130_fd_sc_hd__diode_2
XANTENNA__5926__RESET_B fanout307/X VGND VGND VPWR VPWR sky130_fd_sc_hd__diode_2
Xmax_cap180 _2788_/Y VGND VGND VPWR VPWR fanout179/A sky130_fd_sc_hd__clkbuf_1
Xhold450 _5656_/Q VGND VGND VPWR VPWR hold450/X sky130_fd_sc_hd__dlygate4sd3_1
Xhold472 _6046_/Q VGND VGND VPWR VPWR _5123_/A sky130_fd_sc_hd__dlygate4sd3_1
XANTENNA__4690__A0 _5793_/Q VGND VGND VPWR VPWR sky130_fd_sc_hd__diode_2
XFILLER_57_151 VGND VGND VPWR VPWR sky130_fd_sc_hd__fill_1
XANTENNA__3493__B2 _6144_/D VGND VGND VPWR VPWR sky130_fd_sc_hd__diode_2
XTAP_TAPCELL_ROW_28_533 VGND VPWR sky130_fd_sc_hd__tapvpwrvgnd_1
XTAP_TAPCELL_ROW_56_875 VGND VPWR sky130_fd_sc_hd__tapvpwrvgnd_1
XTAP_TAPCELL_ROW_56_886 VGND VPWR sky130_fd_sc_hd__tapvpwrvgnd_1
XFILLER_54_53 VGND VGND VPWR VPWR sky130_fd_sc_hd__fill_2
XTAP_TAPCELL_ROW_0_180 VGND VPWR sky130_fd_sc_hd__tapvpwrvgnd_1
XFILLER_54_97 VPWR VGND VPWR VGND sky130_ef_sc_hd__decap_12
XANTENNA__5200__D _6167_/Q VGND VGND VPWR VPWR sky130_fd_sc_hd__diode_2
XFILLER_41_563 VGND VGND VPWR VPWR sky130_fd_sc_hd__decap_8
XANTENNA__5493__Q _5493_/Q VGND VGND VPWR VPWR sky130_fd_sc_hd__diode_2
XANTENNA__5209__B _6129_/D VGND VGND VPWR VPWR sky130_fd_sc_hd__diode_2
Xclkload17 _5811_/CLK VGND VGND VPWR VPWR clkload17/Y sky130_fd_sc_hd__clkinv_8
Xclkload39 _6161_/CLK VGND VGND VPWR VPWR clkload39/Y sky130_fd_sc_hd__clkinv_8
Xclkload28 _6163_/CLK VGND VGND VPWR VPWR clkload28/Y sky130_fd_sc_hd__inv_6
XANTENNA__5170__A1 _5476_/Q VGND VGND VPWR VPWR sky130_fd_sc_hd__diode_2
XFILLER_68_438 VGND VGND VPWR VPWR sky130_fd_sc_hd__fill_2
XTAP_TAPCELL_ROW_8_280 VGND VPWR sky130_fd_sc_hd__tapvpwrvgnd_1
Xclkbuf_leaf_0_clk clkload0/A VGND VGND VPWR VPWR clkload3/A sky130_fd_sc_hd__clkbuf_8
X_3020_ _3018_/X _3019_/X _3953_/B VGND VGND VPWR VPWR _3020_/X sky130_fd_sc_hd__mux2_1
XANTENNA__3032__X _6143_/D VGND VGND VPWR VPWR sky130_fd_sc_hd__diode_2
X_4971_ _4743_/X _4971_/A2 _4971_/B1 _4970_/X VGND VGND VPWR VPWR _4971_/X sky130_fd_sc_hd__a22o_1
XFILLER_64_699 VGND VGND VPWR VPWR sky130_fd_sc_hd__fill_1
XFILLER_51_327 VGND VGND VPWR VPWR sky130_fd_sc_hd__fill_1
XANTENNA__4984__B2 _4886_/X VGND VGND VPWR VPWR sky130_fd_sc_hd__diode_2
X_3922_ _5585_/Q _2955_/Y _3548_/Y _3918_/X VGND VGND VPWR VPWR _5585_/D sky130_fd_sc_hd__a22o_1
X_3853_ _3626_/A _3725_/C _3852_/X _3905_/B VGND VGND VPWR VPWR _3853_/X sky130_fd_sc_hd__a211o_1
X_2804_ _2925_/B _5887_/Q _2895_/A _2871_/B VGND VGND VPWR VPWR _2804_/X sky130_fd_sc_hd__and4b_1
XANTENNA__4736__A1 _4226_/S VGND VGND VPWR VPWR sky130_fd_sc_hd__diode_2
X_3784_ _5200_/C _3869_/B _3893_/C VGND VGND VPWR VPWR _4098_/D sky130_fd_sc_hd__and3_1
X_5523_ _6085_/CLK _5523_/D fanout331/X VGND VGND VPWR VPWR _5523_/Q sky130_fd_sc_hd__dfrtp_4
X_2735_ _5613_/Q VGND VGND VPWR VPWR _3408_/B sky130_fd_sc_hd__inv_2
X_5454_ _5451_/A _5450_/B _5446_/X VGND VGND VPWR VPWR _5454_/X sky130_fd_sc_hd__a21o_1
XANTENNA__5161__A1 _5471_/Q VGND VGND VPWR VPWR sky130_fd_sc_hd__diode_2
X_4405_ _4404_/A _4404_/B _3706_/X VGND VGND VPWR VPWR _4405_/Y sky130_fd_sc_hd__a21boi_1
X_5385_ _5385_/A _5385_/B VGND VGND VPWR VPWR _5387_/A sky130_fd_sc_hd__nor2_1
X_4336_ _2934_/B _5733_/Q _4336_/S VGND VGND VPWR VPWR _5728_/D sky130_fd_sc_hd__mux2_1
Xfanout204 _6112_/Q VGND VGND VPWR VPWR _2871_/C sky130_fd_sc_hd__buf_2
Xfanout237 _5747_/Q VGND VGND VPWR VPWR _3639_/A sky130_fd_sc_hd__clkbuf_4
Xfanout226 _3725_/A VGND VGND VPWR VPWR _3900_/A sky130_fd_sc_hd__buf_1
Xfanout215 _6047_/Q VGND VGND VPWR VPWR _3128_/B sky130_fd_sc_hd__clkbuf_2
Xfanout259 _5725_/Q VGND VGND VPWR VPWR _2824_/C sky130_fd_sc_hd__clkbuf_4
XTAP_TAPCELL_ROW_70_1059 VGND VPWR sky130_fd_sc_hd__tapvpwrvgnd_1
X_4267_ _4263_/X _4264_/X _4266_/Y _5717_/Q VGND VGND VPWR VPWR _4267_/X sky130_fd_sc_hd__o22a_1
Xfanout248 _3651_/B VGND VGND VPWR VPWR _4424_/A sky130_fd_sc_hd__clkbuf_2
X_6006_ _6091_/CLK _6006_/D fanout348/X VGND VGND VPWR VPWR _6006_/Q sky130_fd_sc_hd__dfrtp_1
X_4198_ _4197_/X _4193_/X _4234_/S VGND VGND VPWR VPWR _4198_/X sky130_fd_sc_hd__mux2_1
X_3218_ hold46/X _5641_/Q _3219_/S VGND VGND VPWR VPWR _5485_/D sky130_fd_sc_hd__mux2_1
X_3149_ _2934_/B _2996_/Y _3148_/X VGND VGND VPWR VPWR _3149_/X sky130_fd_sc_hd__a21o_1
XFILLER_27_335 VGND VGND VPWR VPWR sky130_fd_sc_hd__fill_1
XANTENNA__3227__A1 _5492_/Q VGND VGND VPWR VPWR sky130_fd_sc_hd__diode_2
XPHY_EDGE_ROW_59_Left_140 VGND VGND VPWR VPWR sky130_fd_sc_hd__decap_3
XTAP_TAPCELL_ROW_53_845 VGND VPWR sky130_fd_sc_hd__tapvpwrvgnd_1
XFILLER_24_45 VGND VGND VPWR VPWR sky130_fd_sc_hd__fill_1
XFILLER_10_257 VGND VGND VPWR VPWR sky130_fd_sc_hd__fill_1
XTAP_TAPCELL_ROW_33_591 VGND VPWR sky130_fd_sc_hd__tapvpwrvgnd_1
XFILLER_6_239 VPWR VGND VPWR VGND sky130_ef_sc_hd__decap_12
XANTENNA__5152__A1 _5490_/Q VGND VGND VPWR VPWR sky130_fd_sc_hd__diode_2
Xhold280 _5827_/Q VGND VGND VPWR VPWR hold280/X sky130_fd_sc_hd__dlygate4sd3_1
XFILLER_6_3 VGND VGND VPWR VPWR sky130_fd_sc_hd__decap_4
XFILLER_2_445 VPWR VGND VPWR VGND sky130_ef_sc_hd__decap_12
Xhold291 _5781_/Q VGND VGND VPWR VPWR hold291/X sky130_fd_sc_hd__dlygate4sd3_1
XFILLER_1_27 VPWR VGND VPWR VGND sky130_ef_sc_hd__decap_12
XFILLER_65_74 VGND VGND VPWR VPWR sky130_fd_sc_hd__decap_3
XFILLER_65_96 VGND VGND VPWR VPWR sky130_fd_sc_hd__decap_4
XFILLER_60_113 VPWR VGND VPWR VGND sky130_ef_sc_hd__decap_12
XANTENNA__5488__Q _5488_/Q VGND VGND VPWR VPWR sky130_fd_sc_hd__diode_2
XFILLER_60_135 VGND VGND VPWR VPWR sky130_fd_sc_hd__decap_4
XANTENNA__4718__A1 _4750_/A1 VGND VGND VPWR VPWR sky130_fd_sc_hd__diode_2
XANTENNA__3439__S _3442_/S VGND VGND VPWR VPWR sky130_fd_sc_hd__diode_2
XANTENNA__4194__A2 _4167_/Y VGND VGND VPWR VPWR sky130_fd_sc_hd__diode_2
XANTENNA_clkbuf_leaf_17_clk_A clkbuf_leaf_9_clk/A VGND VGND VPWR VPWR sky130_fd_sc_hd__diode_2
X_5170_ hold182/X _5476_/Q _5170_/S VGND VGND VPWR VPWR _6092_/D sky130_fd_sc_hd__mux2_1
XFILLER_39_3 VPWR VGND VPWR VGND sky130_ef_sc_hd__decap_12
XFILLER_68_235 VGND VGND VPWR VPWR sky130_fd_sc_hd__fill_1
X_4121_ _4097_/Y _4098_/X _4116_/X _4117_/Y VGND VGND VPWR VPWR _4130_/C sky130_fd_sc_hd__a211o_1
X_4052_ hold33/A hold69/A _4052_/S VGND VGND VPWR VPWR _4052_/X sky130_fd_sc_hd__mux2_1
Xinput4 uio_in[3] VGND VGND VPWR VPWR input4/X sky130_fd_sc_hd__clkbuf_1
XANTENNA__4654__B1 _4678_/C1 VGND VGND VPWR VPWR sky130_fd_sc_hd__diode_2
X_3003_ hold61/A hold48/A hold71/A hold67/A _5609_/Q _3955_/A VGND VGND VPWR VPWR
+ _3003_/X sky130_fd_sc_hd__mux4_1
XFILLER_36_132 VGND VGND VPWR VPWR sky130_fd_sc_hd__fill_2
XFILLER_36_143 VPWR VGND VPWR VGND sky130_ef_sc_hd__decap_12
XFILLER_37_644 VGND VGND VPWR VPWR sky130_fd_sc_hd__decap_4
Xclkbuf_2_1__f_clk clkbuf_0_clk/X VGND VGND VPWR VPWR clkbuf_leaf_9_clk/A sky130_fd_sc_hd__clkbuf_16
X_4954_ hold384/X _4972_/A2 _4953_/X VGND VGND VPWR VPWR _5927_/D sky130_fd_sc_hd__a21o_1
XANTENNA__4733__S _4735_/S VGND VGND VPWR VPWR sky130_fd_sc_hd__diode_2
XFILLER_51_146 VGND VGND VPWR VPWR sky130_fd_sc_hd__fill_1
XFILLER_51_113 VGND VGND VPWR VPWR sky130_fd_sc_hd__decap_4
XTAP_TAPCELL_ROW_50_804 VGND VPWR sky130_fd_sc_hd__tapvpwrvgnd_1
X_3905_ _3905_/A _3905_/B _3905_/C VGND VGND VPWR VPWR _3905_/X sky130_fd_sc_hd__and3_1
XANTENNA__3857__B _3905_/B VGND VGND VPWR VPWR sky130_fd_sc_hd__diode_2
X_4885_ _5904_/Q _4975_/A2 _4884_/X VGND VGND VPWR VPWR _5904_/D sky130_fd_sc_hd__a21o_1
X_3836_ _4127_/B _4127_/C _3773_/A VGND VGND VPWR VPWR _3836_/X sky130_fd_sc_hd__a21o_1
X_3767_ _3767_/A VGND VGND VPWR VPWR _3767_/Y sky130_fd_sc_hd__inv_2
XTAP_TAPCELL_ROW_30_550 VGND VPWR sky130_fd_sc_hd__tapvpwrvgnd_1
XTAP_TAPCELL_ROW_30_561 VGND VPWR sky130_fd_sc_hd__tapvpwrvgnd_1
XANTENNA__5589__RESET_B fanout313/X VGND VGND VPWR VPWR sky130_fd_sc_hd__diode_2
XANTENNA_fanout300_A fanout303/X VGND VGND VPWR VPWR sky130_fd_sc_hd__diode_2
X_5506_ clkload4/A _5506_/D fanout278/X VGND VGND VPWR VPWR _5506_/Q sky130_fd_sc_hd__dfrtp_1
X_3698_ _3698_/A _3698_/B _3698_/C _3698_/D VGND VGND VPWR VPWR _3721_/C sky130_fd_sc_hd__or4_1
X_5437_ _5428_/A _5431_/Y _5436_/Y VGND VGND VPWR VPWR _5437_/Y sky130_fd_sc_hd__a21oi_1
XANTENNA__3696__A1 _4428_/A VGND VGND VPWR VPWR sky130_fd_sc_hd__diode_2
X_5368_ _5369_/A _5453_/B VGND VGND VPWR VPWR _5372_/A sky130_fd_sc_hd__and2_1
X_4319_ _4319_/A _4319_/B VGND VGND VPWR VPWR _4338_/B sky130_fd_sc_hd__nand2_1
XANTENNA__3160__A3 _4964_/A0 VGND VGND VPWR VPWR sky130_fd_sc_hd__diode_2
X_5299_ _6153_/Q _5343_/B VGND VGND VPWR VPWR _5300_/A sky130_fd_sc_hd__xor2_1
XFILLER_59_279 VGND VGND VPWR VPWR sky130_fd_sc_hd__fill_1
XTAP_TAPCELL_ROW_58_904 VGND VPWR sky130_fd_sc_hd__tapvpwrvgnd_1
XFILLER_15_305 VGND VGND VPWR VPWR sky130_fd_sc_hd__fill_1
XTAP_TAPCELL_ROW_38_650 VGND VPWR sky130_fd_sc_hd__tapvpwrvgnd_1
XTAP_TAPCELL_ROW_38_661 VGND VPWR sky130_fd_sc_hd__tapvpwrvgnd_1
XFILLER_15_349 VPWR VGND VPWR VGND sky130_ef_sc_hd__decap_12
XFILLER_35_55 VGND VGND VPWR VPWR sky130_fd_sc_hd__fill_1
XANTENNA__4879__A _4943_/S VGND VGND VPWR VPWR sky130_fd_sc_hd__diode_2
XANTENNA__3923__A2 _3240_/B VGND VGND VPWR VPWR sky130_fd_sc_hd__diode_2
XANTENNA__3783__A _3783_/A VGND VGND VPWR VPWR sky130_fd_sc_hd__diode_2
XFILLER_2_253 VGND VGND VPWR VPWR sky130_fd_sc_hd__fill_1
XANTENNA__2925__A_N _2871_/B VGND VGND VPWR VPWR sky130_fd_sc_hd__diode_2
XANTENNA__4884__B1 _4878_/B VGND VGND VPWR VPWR sky130_fd_sc_hd__diode_2
XFILLER_76_51 VGND VGND VPWR VPWR sky130_fd_sc_hd__fill_1
XFILLER_25_9 VGND VGND VPWR VPWR sky130_fd_sc_hd__fill_1
XFILLER_65_216 VGND VGND VPWR VPWR sky130_fd_sc_hd__fill_1
XANTENNA__4636__B1 _4243_/S VGND VGND VPWR VPWR sky130_fd_sc_hd__diode_2
XFILLER_46_474 VGND VGND VPWR VPWR sky130_fd_sc_hd__fill_2
XFILLER_61_433 VGND VGND VPWR VPWR sky130_fd_sc_hd__fill_1
XFILLER_33_113 VGND VGND VPWR VPWR sky130_fd_sc_hd__decap_8
XFILLER_14_360 VGND VGND VPWR VPWR sky130_fd_sc_hd__decap_4
XTAP_TAPCELL_ROW_16_377 VGND VPWR sky130_fd_sc_hd__tapvpwrvgnd_1
X_4670_ _4750_/A1 _4669_/X _4668_/X _4750_/C1 VGND VGND VPWR VPWR _4670_/X sky130_fd_sc_hd__o211a_1
X_3621_ _4536_/A _5978_/Q VGND VGND VPWR VPWR _3718_/A sky130_fd_sc_hd__xor2_1
XANTENNA__3375__B1 _4544_/A VGND VGND VPWR VPWR sky130_fd_sc_hd__diode_2
X_3552_ _3519_/X _3521_/Y _3550_/B VGND VGND VPWR VPWR _3552_/Y sky130_fd_sc_hd__a21oi_2
X_3483_ _3483_/A _3483_/B VGND VGND VPWR VPWR _5226_/B sky130_fd_sc_hd__nand2_1
X_5222_ _5223_/B _5222_/B VGND VGND VPWR VPWR _6126_/D sky130_fd_sc_hd__and2_1
XANTENNA__3678__A1 _4399_/A VGND VGND VPWR VPWR sky130_fd_sc_hd__diode_2
X_5153_ hold207/X _5491_/Q _5167_/S VGND VGND VPWR VPWR _6075_/D sky130_fd_sc_hd__mux2_1
XANTENNA__3678__B2 _4428_/A VGND VGND VPWR VPWR sky130_fd_sc_hd__diode_2
X_4104_ _4102_/B _4102_/C _5576_/Q VGND VGND VPWR VPWR _4104_/Y sky130_fd_sc_hd__a21oi_1
X_5084_ hold218/X _5467_/Q _5099_/S VGND VGND VPWR VPWR _6007_/D sky130_fd_sc_hd__mux2_1
X_4035_ _4074_/S1 _4034_/X _4033_/X _4542_/A VGND VGND VPWR VPWR _4035_/X sky130_fd_sc_hd__a211o_1
XFILLER_25_625 VGND VGND VPWR VPWR sky130_fd_sc_hd__decap_3
XFILLER_64_282 VGND VGND VPWR VPWR sky130_fd_sc_hd__fill_1
XTAP_TAPCELL_ROW_35_620 VGND VPWR sky130_fd_sc_hd__tapvpwrvgnd_1
XANTENNA_fanout348_A fanout351/X VGND VGND VPWR VPWR sky130_fd_sc_hd__diode_2
XTAP_TAPCELL_ROW_63_973 VGND VPWR sky130_fd_sc_hd__tapvpwrvgnd_1
XTAP_TAPCELL_ROW_63_962 VGND VPWR sky130_fd_sc_hd__tapvpwrvgnd_1
XANTENNA__3587__B _4452_/A VGND VGND VPWR VPWR sky130_fd_sc_hd__diode_2
X_5986_ _6110_/CLK _5986_/D fanout299/X VGND VGND VPWR VPWR _5986_/Q sky130_fd_sc_hd__dfrtp_1
X_4937_ _5470_/Q _4650_/X _4949_/S VGND VGND VPWR VPWR _4937_/X sky130_fd_sc_hd__mux2_1
X_4868_ _4865_/A _4865_/B _4867_/Y _2720_/Y _5900_/Q VGND VGND VPWR VPWR _5900_/D
+ sky130_fd_sc_hd__a32o_1
XANTENNA_fanout136_X _3240_/B VGND VGND VPWR VPWR sky130_fd_sc_hd__diode_2
X_3819_ _3380_/X _3767_/A _3816_/X _3783_/A VGND VGND VPWR VPWR _4100_/B sky130_fd_sc_hd__a22oi_2
X_4799_ _5471_/Q hold226/X _4807_/S VGND VGND VPWR VPWR _5836_/D sky130_fd_sc_hd__mux2_1
XFILLER_20_396 VGND VGND VPWR VPWR sky130_fd_sc_hd__decap_8
XANTENNA_fanout303_X fanout303/X VGND VGND VPWR VPWR sky130_fd_sc_hd__diode_2
XANTENNA__5107__A1 _5427_/A VGND VGND VPWR VPWR sky130_fd_sc_hd__diode_2
XANTENNA__3133__A3 _4735_/S VGND VGND VPWR VPWR sky130_fd_sc_hd__diode_2
XANTENNA__2892__A2 _2917_/A2 VGND VGND VPWR VPWR sky130_fd_sc_hd__diode_2
XANTENNA__4618__A0 _5494_/Q VGND VGND VPWR VPWR sky130_fd_sc_hd__diode_2
XFILLER_46_65 VGND VGND VPWR VPWR sky130_fd_sc_hd__fill_1
XANTENNA__3841__A1 _6171_/Q VGND VGND VPWR VPWR sky130_fd_sc_hd__diode_2
XANTENNA_fanout49_X _3877_/S VGND VGND VPWR VPWR sky130_fd_sc_hd__diode_2
XANTENNA__5766__Q _5766_/Q VGND VGND VPWR VPWR sky130_fd_sc_hd__diode_2
XTAP_TAPCELL_ROW_13_347 VGND VPWR sky130_fd_sc_hd__tapvpwrvgnd_1
XFILLER_30_149 VGND VGND VPWR VPWR sky130_fd_sc_hd__decap_4
XTAP_TAPCELL_ROW_41_689 VGND VPWR sky130_fd_sc_hd__tapvpwrvgnd_1
XFILLER_7_48 VGND VGND VPWR VPWR sky130_fd_sc_hd__fill_1
XANTENNA__4857__A0 _2824_/C VGND VGND VPWR VPWR sky130_fd_sc_hd__diode_2
XFILLER_30_7 VGND VGND VPWR VPWR sky130_fd_sc_hd__fill_1
XANTENNA__4609__B1 _4608_/X VGND VGND VPWR VPWR sky130_fd_sc_hd__diode_2
XTAP_TAPCELL_ROW_49_789 VGND VPWR sky130_fd_sc_hd__tapvpwrvgnd_1
XFILLER_34_433 VGND VGND VPWR VPWR sky130_fd_sc_hd__decap_4
X_5840_ _6093_/CLK _5840_/D fanout345/X VGND VGND VPWR VPWR _5840_/Q sky130_fd_sc_hd__dfrtp_1
XFILLER_22_617 VPWR VGND VPWR VGND sky130_ef_sc_hd__decap_12
XTAP_TAPCELL_ROW_60_932 VGND VPWR sky130_fd_sc_hd__tapvpwrvgnd_1
X_5771_ _6032_/CLK _5771_/D fanout300/X VGND VGND VPWR VPWR _5771_/Q sky130_fd_sc_hd__dfrtp_1
X_2983_ _4977_/A _4623_/S VGND VGND VPWR VPWR _2988_/B sky130_fd_sc_hd__and2_2
X_4722_ _5797_/Q _4964_/A0 _4746_/S VGND VGND VPWR VPWR _4722_/X sky130_fd_sc_hd__mux2_1
X_4653_ _5955_/Q _5763_/Q _4679_/S VGND VGND VPWR VPWR _4653_/X sky130_fd_sc_hd__mux2_1
X_4584_ _4672_/A1 _4583_/X _4582_/X _4704_/C1 VGND VGND VPWR VPWR _4584_/X sky130_fd_sc_hd__a211o_1
X_3604_ _4464_/A _6056_/Q _6058_/Q _4491_/A VGND VGND VPWR VPWR _3712_/B sky130_fd_sc_hd__a22o_1
X_3535_ _3528_/B _3528_/C _3502_/Y VGND VGND VPWR VPWR _3535_/Y sky130_fd_sc_hd__a21boi_1
XANTENNA__5127__B _5127_/B VGND VGND VPWR VPWR sky130_fd_sc_hd__diode_2
X_3466_ _6154_/Q _6153_/Q _6156_/Q _6155_/Q VGND VGND VPWR VPWR _3467_/D sky130_fd_sc_hd__or4_1
XANTENNA__4848__A0 _5494_/Q VGND VGND VPWR VPWR sky130_fd_sc_hd__diode_2
X_5205_ _3475_/A _5237_/A _5204_/X VGND VGND VPWR VPWR _5205_/X sky130_fd_sc_hd__a21o_1
XANTENNA_fanout298_A fanout309/X VGND VGND VPWR VPWR sky130_fd_sc_hd__diode_2
X_3397_ hold89/X _3397_/A2 _3725_/B VGND VGND VPWR VPWR _5516_/D sky130_fd_sc_hd__a21o_1
X_5136_ hold248/X _3647_/A _5137_/S VGND VGND VPWR VPWR _6059_/D sky130_fd_sc_hd__mux2_1
XANTENNA__2874__A2 _2783_/B VGND VGND VPWR VPWR sky130_fd_sc_hd__diode_2
X_5067_ _5758_/Q _5067_/B _5768_/Q _5759_/Q VGND VGND VPWR VPWR _5067_/X sky130_fd_sc_hd__and4b_1
X_4018_ _5651_/Q _4019_/C _5652_/Q VGND VGND VPWR VPWR _4020_/B sky130_fd_sc_hd__a21oi_1
XFILLER_16_46 VPWR VGND VPWR VGND sky130_ef_sc_hd__decap_12
XANTENNA_fanout253_X _4813_/A1 VGND VGND VPWR VPWR sky130_fd_sc_hd__diode_2
X_5969_ clkload3/A _5969_/D fanout272/X VGND VGND VPWR VPWR _5969_/Q sky130_fd_sc_hd__dfrtp_1
XFILLER_25_499 VGND VGND VPWR VPWR sky130_fd_sc_hd__decap_4
XTAP_TAPCELL_ROW_10_306 VGND VPWR sky130_fd_sc_hd__tapvpwrvgnd_1
XTAP_TAPCELL_ROW_78_1149 VGND VPWR sky130_fd_sc_hd__tapvpwrvgnd_1
XANTENNA__4839__A0 _5523_/Q VGND VGND VPWR VPWR sky130_fd_sc_hd__diode_2
XANTENNA__3780__B _3913_/B VGND VGND VPWR VPWR sky130_fd_sc_hd__diode_2
XFILLER_75_311 VGND VGND VPWR VPWR sky130_fd_sc_hd__fill_1
XFILLER_0_587 VGND VGND VPWR VPWR sky130_fd_sc_hd__fill_1
XFILLER_75_366 VGND VGND VPWR VPWR sky130_fd_sc_hd__decap_3
XFILLER_57_97 VGND VGND VPWR VPWR sky130_fd_sc_hd__fill_1
XTAP_TAPCELL_ROW_18_406 VGND VPWR sky130_fd_sc_hd__tapvpwrvgnd_1
XTAP_TAPCELL_ROW_46_759 VGND VPWR sky130_fd_sc_hd__tapvpwrvgnd_1
XANTENNA__5016__B1 _5024_/B1 VGND VGND VPWR VPWR sky130_fd_sc_hd__diode_2
XFILLER_31_447 VGND VGND VPWR VPWR sky130_fd_sc_hd__fill_1
XFILLER_8_643 VGND VGND VPWR VPWR sky130_fd_sc_hd__fill_1
XANTENNA__4132__A _4164_/B VGND VGND VPWR VPWR sky130_fd_sc_hd__diode_2
Xhold109 _5991_/Q VGND VGND VPWR VPWR hold109/X sky130_fd_sc_hd__dlygate4sd3_1
X_3320_ _3298_/A _5985_/Q _3364_/D _3361_/B _3345_/B VGND VGND VPWR VPWR _3325_/A
+ sky130_fd_sc_hd__a2111o_1
XFILLER_3_381 VGND VGND VPWR VPWR sky130_fd_sc_hd__decap_3
X_3251_ _4350_/A _4342_/A VGND VGND VPWR VPWR _5203_/A sky130_fd_sc_hd__nor2_1
X_3182_ _3182_/A1 _3181_/Y _3183_/B VGND VGND VPWR VPWR _6196_/A sky130_fd_sc_hd__o21a_2
XFILLER_21_3 VGND VGND VPWR VPWR sky130_fd_sc_hd__decap_8
XANTENNA__3805__A1 _5397_/A VGND VGND VPWR VPWR sky130_fd_sc_hd__diode_2
X_5823_ _6094_/CLK _5823_/D fanout349/X VGND VGND VPWR VPWR _5823_/Q sky130_fd_sc_hd__dfrtp_1
XFILLER_50_712 VGND VGND VPWR VPWR sky130_fd_sc_hd__fill_1
XPHY_EDGE_ROW_22_Left_103 VGND VGND VPWR VPWR sky130_fd_sc_hd__decap_3
X_5754_ _6026_/CLK _5754_/D fanout277/X VGND VGND VPWR VPWR _5754_/Q sky130_fd_sc_hd__dfrtp_4
X_2966_ _6110_/Q _4978_/C VGND VGND VPWR VPWR _3138_/B sky130_fd_sc_hd__nand2_4
X_2897_ _6021_/Q _2886_/B _2918_/B1 _6013_/Q VGND VGND VPWR VPWR _2897_/X sky130_fd_sc_hd__a22o_1
X_4705_ hold206/X _4737_/A2 _4704_/X VGND VGND VPWR VPWR _5786_/D sky130_fd_sc_hd__o21a_1
X_5685_ _5685_/CLK hold78/X VGND VGND VPWR VPWR _5685_/Q sky130_fd_sc_hd__dfxtp_1
X_4636_ _5953_/Q _4748_/A2 _4243_/S _4635_/X VGND VGND VPWR VPWR _4636_/X sky130_fd_sc_hd__a211o_1
X_4567_ _5911_/Q _5760_/Q _4615_/S VGND VGND VPWR VPWR _4567_/X sky130_fd_sc_hd__mux2_1
XPHY_EDGE_ROW_31_Left_112 VGND VGND VPWR VPWR sky130_fd_sc_hd__decap_3
X_4498_ _4522_/A _4522_/D VGND VGND VPWR VPWR _4499_/B sky130_fd_sc_hd__xnor2_1
X_3518_ _3126_/A _3126_/B _3492_/X VGND VGND VPWR VPWR _3521_/C sky130_fd_sc_hd__a21bo_1
X_3449_ _5587_/Q hold65/X _3451_/S VGND VGND VPWR VPWR _5562_/D sky130_fd_sc_hd__mux2_1
X_6168_ clkload8/A _6168_/D fanout285/X VGND VGND VPWR VPWR _6168_/Q sky130_fd_sc_hd__dfrtp_1
X_5119_ hold337/X _3639_/A _5122_/S VGND VGND VPWR VPWR _6042_/D sky130_fd_sc_hd__mux2_1
XFILLER_18_709 VGND VGND VPWR VPWR sky130_fd_sc_hd__decap_4
X_6099_ _6107_/CLK _6099_/D fanout273/X VGND VGND VPWR VPWR _6099_/Q sky130_fd_sc_hd__dfrtp_1
XFILLER_45_517 VGND VGND VPWR VPWR sky130_fd_sc_hd__fill_1
XPHY_EDGE_ROW_40_Left_121 VGND VGND VPWR VPWR sky130_fd_sc_hd__decap_3
XFILLER_45_539 VGND VGND VPWR VPWR sky130_fd_sc_hd__fill_1
XFILLER_72_369 VGND VGND VPWR VPWR sky130_fd_sc_hd__fill_1
XFILLER_25_263 VPWR VGND VPWR VGND sky130_ef_sc_hd__decap_12
XTAP_TAPCELL_ROW_43_718 VGND VPWR sky130_fd_sc_hd__tapvpwrvgnd_1
XFILLER_80_391 VGND VGND VPWR VPWR sky130_fd_sc_hd__fill_1
XFILLER_43_55 VGND VGND VPWR VPWR sky130_fd_sc_hd__fill_1
XTAP_TAPCELL_ROW_23_464 VGND VPWR sky130_fd_sc_hd__tapvpwrvgnd_1
XFILLER_21_480 VGND VGND VPWR VPWR sky130_fd_sc_hd__decap_8
XFILLER_5_668 VGND VGND VPWR VPWR sky130_fd_sc_hd__decap_4
XFILLER_68_85 VGND VGND VPWR VPWR sky130_fd_sc_hd__fill_2
XFILLER_0_340 VPWR VGND VPWR VGND sky130_ef_sc_hd__decap_12
XFILLER_75_141 VGND VGND VPWR VPWR sky130_fd_sc_hd__fill_2
XFILLER_16_241 VGND VGND VPWR VPWR sky130_fd_sc_hd__decap_4
XFILLER_32_712 VGND VGND VPWR VPWR sky130_fd_sc_hd__fill_1
X_2820_ _2783_/X _2819_/X _5192_/A2 _2722_/Y VGND VGND VPWR VPWR _2820_/X sky130_fd_sc_hd__a211o_1
XANTENNA__4763__A2 _3746_/X VGND VGND VPWR VPWR sky130_fd_sc_hd__diode_2
X_2751_ _3749_/A VGND VGND VPWR VPWR _4175_/C sky130_fd_sc_hd__inv_2
X_5470_ _6021_/CLK _5470_/D fanout332/X VGND VGND VPWR VPWR _5470_/Q sky130_fd_sc_hd__dfrtp_4
XFILLER_69_3 VGND VGND VPWR VPWR sky130_fd_sc_hd__decap_8
X_4421_ _4424_/A _4420_/B _3706_/X VGND VGND VPWR VPWR _4421_/Y sky130_fd_sc_hd__a21boi_1
XANTENNA__4515__A2 _4475_/B VGND VGND VPWR VPWR sky130_fd_sc_hd__diode_2
X_4352_ _6109_/Q _5736_/Q VGND VGND VPWR VPWR _4353_/A sky130_fd_sc_hd__xor2_1
X_4283_ _5569_/Q _5577_/Q _4307_/S VGND VGND VPWR VPWR _4283_/X sky130_fd_sc_hd__mux2_1
X_3303_ _5200_/C _3305_/B _3361_/A _3360_/A _3364_/A VGND VGND VPWR VPWR _3303_/X
+ sky130_fd_sc_hd__a2111o_1
X_6022_ _6094_/CLK _6022_/D fanout349/X VGND VGND VPWR VPWR _6022_/Q sky130_fd_sc_hd__dfrtp_1
XANTENNA__3591__A_N _3647_/A VGND VGND VPWR VPWR sky130_fd_sc_hd__diode_2
X_3234_ _5638_/Q hold38/X _3238_/S VGND VGND VPWR VPWR _5498_/D sky130_fd_sc_hd__mux2_1
XFILLER_66_141 VGND VGND VPWR VPWR sky130_fd_sc_hd__decap_6
X_3165_ _5932_/Q _3144_/B _2980_/Y _5941_/Q _2977_/Y VGND VGND VPWR VPWR _3165_/X
+ sky130_fd_sc_hd__a221o_1
XANTENNA__5421__A _6171_/Q VGND VGND VPWR VPWR sky130_fd_sc_hd__diode_2
XFILLER_39_366 VGND VGND VPWR VPWR sky130_fd_sc_hd__decap_6
X_3096_ _5680_/Q _3097_/C _3095_/Y VGND VGND VPWR VPWR _5680_/D sky130_fd_sc_hd__o21a_1
XANTENNA__4451__A1 _4447_/B VGND VGND VPWR VPWR sky130_fd_sc_hd__diode_2
Xfanout15 _3759_/S VGND VGND VPWR VPWR _3826_/S sky130_fd_sc_hd__buf_2
Xfanout26 _4176_/X VGND VGND VPWR VPWR _4226_/S sky130_fd_sc_hd__clkbuf_4
Xfanout37 _4829_/B VGND VGND VPWR VPWR _3725_/C sky130_fd_sc_hd__buf_2
XFILLER_22_222 VGND VGND VPWR VPWR sky130_fd_sc_hd__fill_1
XFILLER_35_594 VGND VGND VPWR VPWR sky130_fd_sc_hd__fill_1
XANTENNA_fanout330_A fanout334/X VGND VGND VPWR VPWR sky130_fd_sc_hd__diode_2
Xfanout59 _4747_/A2 VGND VGND VPWR VPWR _4684_/A2 sky130_fd_sc_hd__clkbuf_4
Xfanout48 _3877_/S VGND VGND VPWR VPWR _4704_/C1 sky130_fd_sc_hd__clkbuf_4
X_3998_ _5626_/Q _3997_/B _3997_/Y _3996_/A VGND VGND VPWR VPWR _5626_/D sky130_fd_sc_hd__o211a_1
X_5806_ clkload4/A _5806_/D fanout278/X VGND VGND VPWR VPWR _5806_/Q sky130_fd_sc_hd__dfrtp_1
X_5737_ clkload8/A _5737_/D fanout285/X VGND VGND VPWR VPWR _5737_/Q sky130_fd_sc_hd__dfrtp_4
X_2949_ _2949_/A _2949_/B _3968_/S _2949_/D VGND VGND VPWR VPWR _3426_/D sky130_fd_sc_hd__or4_4
XTAP_TAPCELL_ROW_20_434 VGND VPWR sky130_fd_sc_hd__tapvpwrvgnd_1
X_5668_ _6113_/CLK _5668_/D fanout337/X VGND VGND VPWR VPWR _6197_/A sky130_fd_sc_hd__dfstp_1
XTAP_TAPCELL_ROW_75_1119 VGND VPWR sky130_fd_sc_hd__tapvpwrvgnd_1
X_4619_ _5951_/Q _4683_/A2 _4667_/B1 _4618_/X VGND VGND VPWR VPWR _4619_/X sky130_fd_sc_hd__a22o_1
X_5599_ _5686_/CLK _5599_/D fanout321/X VGND VGND VPWR VPWR _5599_/Q sky130_fd_sc_hd__dfrtp_4
Xhold440 _6142_/Q VGND VGND VPWR VPWR hold440/X sky130_fd_sc_hd__dlygate4sd3_1
Xhold462 _5653_/Q VGND VGND VPWR VPWR hold462/X sky130_fd_sc_hd__dlygate4sd3_1
Xhold451 _6028_/Q VGND VGND VPWR VPWR hold451/X sky130_fd_sc_hd__dlygate4sd3_1
Xhold473 _5640_/Q VGND VGND VPWR VPWR hold473/X sky130_fd_sc_hd__dlygate4sd3_1
XANTENNA__5966__RESET_B fanout306/X VGND VGND VPWR VPWR sky130_fd_sc_hd__diode_2
XANTENNA_fanout76_A _4870_/A1 VGND VGND VPWR VPWR sky130_fd_sc_hd__diode_2
XANTENNA__4690__A1 _5725_/Q VGND VGND VPWR VPWR sky130_fd_sc_hd__diode_2
XFILLER_18_528 VGND VGND VPWR VPWR sky130_fd_sc_hd__decap_4
XFILLER_18_539 VGND VGND VPWR VPWR sky130_fd_sc_hd__fill_1
XTAP_TAPCELL_ROW_28_534 VGND VPWR sky130_fd_sc_hd__tapvpwrvgnd_1
XFILLER_33_509 VGND VGND VPWR VPWR sky130_fd_sc_hd__fill_1
XTAP_TAPCELL_ROW_56_876 VGND VPWR sky130_fd_sc_hd__tapvpwrvgnd_1
XTAP_TAPCELL_ROW_0_170 VGND VPWR sky130_fd_sc_hd__tapvpwrvgnd_1
XTAP_TAPCELL_ROW_0_181 VGND VPWR sky130_fd_sc_hd__tapvpwrvgnd_1
XFILLER_14_712 VGND VGND VPWR VPWR sky130_fd_sc_hd__fill_1
XFILLER_9_248 VPWR VGND VPWR VGND sky130_ef_sc_hd__decap_12
Xclkload18 _5707_/CLK VGND VGND VPWR VPWR clkload18/Y sky130_fd_sc_hd__inv_12
XANTENNA__5209__C _6128_/D VGND VGND VPWR VPWR sky130_fd_sc_hd__diode_2
Xclkload29 _6120_/CLK VGND VGND VPWR VPWR clkload29/Y sky130_fd_sc_hd__clkinvlp_4
XTAP_TAPCELL_ROW_8_281 VGND VPWR sky130_fd_sc_hd__tapvpwrvgnd_1
XFILLER_0_181 VPWR VGND VPWR VGND sky130_ef_sc_hd__decap_12
XFILLER_64_645 VGND VGND VPWR VPWR sky130_fd_sc_hd__fill_1
XFILLER_63_111 VGND VGND VPWR VPWR sky130_fd_sc_hd__fill_1
X_4970_ _4970_/A0 _4738_/X _4973_/S VGND VGND VPWR VPWR _4970_/X sky130_fd_sc_hd__mux2_1
XANTENNA__4984__A2 _5038_/A2 VGND VGND VPWR VPWR sky130_fd_sc_hd__diode_2
XFILLER_32_531 VGND VGND VPWR VPWR sky130_fd_sc_hd__fill_1
X_3921_ _5584_/Q _3240_/B _3559_/Y _3918_/X VGND VGND VPWR VPWR _5584_/D sky130_fd_sc_hd__a22o_1
X_3852_ _3900_/A _5856_/Q VGND VGND VPWR VPWR _3852_/X sky130_fd_sc_hd__and2_1
XANTENNA__4197__B1 _4176_/C VGND VGND VPWR VPWR sky130_fd_sc_hd__diode_2
X_2803_ _2803_/A _6115_/Q VGND VGND VPWR VPWR _2803_/Y sky130_fd_sc_hd__nor2_1
X_5522_ _6131_/CLK _5522_/D fanout329/X VGND VGND VPWR VPWR _5522_/Q sky130_fd_sc_hd__dfrtp_4
X_3783_ _3783_/A _3783_/B VGND VGND VPWR VPWR _4098_/C sky130_fd_sc_hd__and2_1
X_2734_ _5599_/Q VGND VGND VPWR VPWR _2734_/Y sky130_fd_sc_hd__inv_2
X_5453_ _6176_/Q _5453_/B VGND VGND VPWR VPWR _5453_/X sky130_fd_sc_hd__xor2_1
X_4404_ _4404_/A _4404_/B VGND VGND VPWR VPWR _4420_/B sky130_fd_sc_hd__or2_1
X_5384_ _6166_/Q _5453_/B VGND VGND VPWR VPWR _5385_/B sky130_fd_sc_hd__nor2_1
X_4335_ _5094_/A1 _5732_/Q _4336_/S VGND VGND VPWR VPWR _5727_/D sky130_fd_sc_hd__mux2_1
Xfanout205 _2871_/B VGND VGND VPWR VPWR _2920_/B sky130_fd_sc_hd__buf_2
Xfanout216 _5899_/Q VGND VGND VPWR VPWR _4866_/S sky130_fd_sc_hd__buf_2
XFILLER_5_92 VGND VGND VPWR VPWR sky130_fd_sc_hd__decap_3
Xfanout238 _3626_/A VGND VGND VPWR VPWR _4487_/B sky130_fd_sc_hd__buf_2
Xfanout227 _5754_/Q VGND VGND VPWR VPWR _3725_/A sky130_fd_sc_hd__clkbuf_2
XTAP_TAPCELL_ROW_70_1049 VGND VPWR sky130_fd_sc_hd__tapvpwrvgnd_1
X_4266_ _4266_/A _4266_/B VGND VGND VPWR VPWR _4266_/Y sky130_fd_sc_hd__nand2_1
Xfanout249 _5741_/Q VGND VGND VPWR VPWR _3651_/B sky130_fd_sc_hd__clkbuf_4
X_6005_ _6021_/CLK _6005_/D fanout344/X VGND VGND VPWR VPWR _6005_/Q sky130_fd_sc_hd__dfrtp_1
XANTENNA__4672__A1 _4672_/A1 VGND VGND VPWR VPWR sky130_fd_sc_hd__diode_2
X_4197_ _5938_/Q _4177_/C _4176_/C _5905_/Q VGND VGND VPWR VPWR _4197_/X sky130_fd_sc_hd__a22o_1
X_3217_ hold20/X _5640_/Q _3219_/S VGND VGND VPWR VPWR _5484_/D sky130_fd_sc_hd__mux2_1
X_3148_ _5490_/Q _4610_/S _4682_/S _5470_/Q _4879_/B VGND VGND VPWR VPWR _3148_/X
+ sky130_fd_sc_hd__a221o_1
XFILLER_55_623 VGND VGND VPWR VPWR sky130_fd_sc_hd__fill_1
XFILLER_27_303 VPWR VGND VPWR VGND sky130_ef_sc_hd__decap_12
XFILLER_39_163 VGND VGND VPWR VPWR sky130_fd_sc_hd__fill_2
XFILLER_27_369 VGND VGND VPWR VPWR sky130_fd_sc_hd__fill_2
X_3079_ _5596_/Q _5682_/Q VGND VGND VPWR VPWR _3081_/C sky130_fd_sc_hd__xor2_1
XTAP_TAPCELL_ROW_53_846 VGND VPWR sky130_fd_sc_hd__tapvpwrvgnd_1
XFILLER_50_350 VGND VGND VPWR VPWR sky130_fd_sc_hd__decap_4
XTAP_TAPCELL_ROW_33_592 VGND VPWR sky130_fd_sc_hd__tapvpwrvgnd_1
XFILLER_40_56 VGND VGND VPWR VPWR sky130_fd_sc_hd__fill_1
XFILLER_2_402 VPWR VGND VPWR VGND sky130_ef_sc_hd__decap_12
Xhold270 _5893_/Q VGND VGND VPWR VPWR hold270/X sky130_fd_sc_hd__dlygate4sd3_1
XFILLER_2_457 VGND VGND VPWR VPWR sky130_fd_sc_hd__decap_3
XANTENNA__4360__B1 _5737_/Q VGND VGND VPWR VPWR sky130_fd_sc_hd__diode_2
Xhold292 _5844_/Q VGND VGND VPWR VPWR hold292/X sky130_fd_sc_hd__dlygate4sd3_1
Xhold281 _5877_/Q VGND VGND VPWR VPWR hold281/X sky130_fd_sc_hd__dlygate4sd3_1
XFILLER_49_87 VGND VGND VPWR VPWR sky130_fd_sc_hd__decap_3
XANTENNA_fanout79_X _4828_/B2 VGND VGND VPWR VPWR sky130_fd_sc_hd__diode_2
XTAP_TAPCELL_ROW_5_240 VGND VPWR sky130_fd_sc_hd__tapvpwrvgnd_1
XANTENNA__4663__A1 _5764_/Q VGND VGND VPWR VPWR sky130_fd_sc_hd__diode_2
XFILLER_1_39 VPWR VGND VPWR VGND sky130_ef_sc_hd__decap_12
XFILLER_65_53 VGND VGND VPWR VPWR sky130_fd_sc_hd__decap_3
XFILLER_18_336 VGND VGND VPWR VPWR sky130_fd_sc_hd__decap_3
XFILLER_18_347 VGND VGND VPWR VPWR sky130_fd_sc_hd__decap_4
XFILLER_61_615 VGND VGND VPWR VPWR sky130_fd_sc_hd__fill_1
XFILLER_60_125 VGND VGND VPWR VPWR sky130_fd_sc_hd__fill_1
XFILLER_14_531 VGND VGND VPWR VPWR sky130_fd_sc_hd__fill_1
XANTENNA__3926__B1 _3564_/A VGND VGND VPWR VPWR sky130_fd_sc_hd__diode_2
XANTENNA_max_cap80_X _3564_/B VGND VGND VPWR VPWR sky130_fd_sc_hd__diode_2
X_4120_ _3810_/A _3810_/B _5572_/Q VGND VGND VPWR VPWR _4120_/Y sky130_fd_sc_hd__a21oi_1
X_4051_ _4074_/S1 _4051_/B VGND VGND VPWR VPWR _4051_/X sky130_fd_sc_hd__and2b_1
Xinput5 uio_in[6] VGND VGND VPWR VPWR input5/X sky130_fd_sc_hd__clkbuf_1
XANTENNA__4654__A1 _4686_/A1 VGND VGND VPWR VPWR sky130_fd_sc_hd__diode_2
X_3002_ _5676_/Q _5593_/Q _2958_/X _5602_/Q VGND VGND VPWR VPWR _3002_/X sky130_fd_sc_hd__a22o_1
XFILLER_36_155 VGND VGND VPWR VPWR sky130_fd_sc_hd__decap_8
XFILLER_36_166 VGND VGND VPWR VPWR sky130_fd_sc_hd__fill_1
X_4953_ _4695_/X _4971_/A2 _4971_/B1 _4952_/X VGND VGND VPWR VPWR _4953_/X sky130_fd_sc_hd__a22o_1
XFILLER_17_391 VGND VGND VPWR VPWR sky130_fd_sc_hd__fill_1
XFILLER_51_169 VGND VGND VPWR VPWR sky130_fd_sc_hd__decap_8
XTAP_TAPCELL_ROW_50_805 VGND VPWR sky130_fd_sc_hd__tapvpwrvgnd_1
X_3904_ _5814_/Q _5515_/Q _3904_/S VGND VGND VPWR VPWR _3904_/X sky130_fd_sc_hd__mux2_1
X_4884_ _4186_/X _4878_/A _4878_/B _4883_/X VGND VGND VPWR VPWR _4884_/X sky130_fd_sc_hd__a22o_1
XFILLER_32_361 VGND VGND VPWR VPWR sky130_fd_sc_hd__fill_1
X_3835_ _5573_/Q _3834_/C _5574_/Q VGND VGND VPWR VPWR _3835_/Y sky130_fd_sc_hd__a21oi_1
XANTENNA_fanout126_A _4877_/X VGND VGND VPWR VPWR sky130_fd_sc_hd__diode_2
XFILLER_20_589 VGND VGND VPWR VPWR sky130_fd_sc_hd__fill_1
XTAP_TAPCELL_ROW_30_551 VGND VPWR sky130_fd_sc_hd__tapvpwrvgnd_1
X_3766_ _3877_/S _3905_/C VGND VGND VPWR VPWR _3766_/Y sky130_fd_sc_hd__nor2_1
XANTENNA__4590__B1 _4678_/C1 VGND VGND VPWR VPWR sky130_fd_sc_hd__diode_2
X_5505_ clkload4/A _5505_/D fanout278/X VGND VGND VPWR VPWR _5505_/Q sky130_fd_sc_hd__dfrtp_1
XFILLER_10_15 VGND VGND VPWR VPWR sky130_fd_sc_hd__fill_1
X_3697_ _3697_/A _3697_/B _3697_/C VGND VGND VPWR VPWR _3721_/B sky130_fd_sc_hd__or3_1
X_5436_ _6173_/Q _5442_/B VGND VGND VPWR VPWR _5436_/Y sky130_fd_sc_hd__nor2_1
X_5367_ _6163_/Q _5441_/B _5366_/X VGND VGND VPWR VPWR _6163_/D sky130_fd_sc_hd__a21bo_1
X_4318_ _4331_/A1 _4316_/X _4317_/X _5719_/Q VGND VGND VPWR VPWR _5719_/D sky130_fd_sc_hd__o2bb2a_1
XANTENNA__4893__B2 _4892_/X VGND VGND VPWR VPWR sky130_fd_sc_hd__diode_2
XFILLER_59_225 VGND VGND VPWR VPWR sky130_fd_sc_hd__fill_1
X_5298_ hold347/X _5341_/B2 _5297_/X VGND VGND VPWR VPWR _6152_/D sky130_fd_sc_hd__a21o_1
X_4249_ _4266_/A _4256_/C VGND VGND VPWR VPWR _4250_/B sky130_fd_sc_hd__nor2_1
XFILLER_59_247 VGND VGND VPWR VPWR sky130_fd_sc_hd__fill_1
XTAP_TAPCELL_ROW_58_905 VGND VPWR sky130_fd_sc_hd__tapvpwrvgnd_1
XANTENNA_fanout283_X fanout283/X VGND VGND VPWR VPWR sky130_fd_sc_hd__diode_2
XANTENNA__4645__A1 _5762_/Q VGND VGND VPWR VPWR sky130_fd_sc_hd__diode_2
XTAP_TAPCELL_ROW_2_210 VGND VPWR sky130_fd_sc_hd__tapvpwrvgnd_1
XFILLER_19_57 VGND VGND VPWR VPWR sky130_fd_sc_hd__fill_1
XANTENNA__3853__C1 _3905_/B VGND VGND VPWR VPWR sky130_fd_sc_hd__diode_2
XFILLER_28_645 VGND VGND VPWR VPWR sky130_fd_sc_hd__fill_1
XTAP_TAPCELL_ROW_38_651 VGND VPWR sky130_fd_sc_hd__tapvpwrvgnd_1
XFILLER_55_497 VGND VGND VPWR VPWR sky130_fd_sc_hd__fill_1
XFILLER_42_158 VGND VGND VPWR VPWR sky130_fd_sc_hd__fill_1
XFILLER_51_681 VGND VGND VPWR VPWR sky130_fd_sc_hd__fill_1
XFILLER_51_11 VGND VGND VPWR VPWR sky130_fd_sc_hd__fill_1
XFILLER_11_556 VGND VGND VPWR VPWR sky130_fd_sc_hd__decap_4
XFILLER_11_545 VGND VGND VPWR VPWR sky130_fd_sc_hd__fill_1
XFILLER_7_505 VGND VGND VPWR VPWR sky130_fd_sc_hd__decap_3
XFILLER_51_55 VGND VGND VPWR VPWR sky130_fd_sc_hd__fill_1
XANTENNA__4333__A0 _2824_/C VGND VGND VPWR VPWR sky130_fd_sc_hd__diode_2
XANTENNA__3136__A1 _5489_/Q VGND VGND VPWR VPWR sky130_fd_sc_hd__diode_2
XFILLER_2_276 VPWR VGND VPWR VGND sky130_ef_sc_hd__decap_12
XFILLER_18_111 VPWR VGND VPWR VGND sky130_ef_sc_hd__decap_12
XANTENNA__4834__S _4863_/S VGND VGND VPWR VPWR sky130_fd_sc_hd__diode_2
XANTENNA__5061__A1 _6171_/Q VGND VGND VPWR VPWR sky130_fd_sc_hd__diode_2
XFILLER_33_169 VGND VGND VPWR VPWR sky130_fd_sc_hd__decap_4
XTAP_TAPCELL_ROW_16_378 VGND VPWR sky130_fd_sc_hd__tapvpwrvgnd_1
XPHY_EDGE_ROW_78_Left_159 VGND VGND VPWR VPWR sky130_fd_sc_hd__decap_3
X_3620_ _5801_/Q _3620_/B _3620_/C VGND VGND VPWR VPWR _3620_/X sky130_fd_sc_hd__and3_1
XANTENNA__4572__B1 _4684_/B1 VGND VGND VPWR VPWR sky130_fd_sc_hd__diode_2
X_3551_ _3521_/B _3521_/C _3545_/A VGND VGND VPWR VPWR _3551_/X sky130_fd_sc_hd__a21o_1
XFILLER_51_3 VGND VGND VPWR VPWR sky130_fd_sc_hd__decap_8
X_3482_ _3256_/X _4350_/B _3245_/B _3549_/A VGND VGND VPWR VPWR _3483_/B sky130_fd_sc_hd__o211a_1
X_5221_ _6125_/Q _5217_/A _5217_/B _6126_/Q VGND VGND VPWR VPWR _5222_/B sky130_fd_sc_hd__a31o_1
X_5152_ hold120/X _5490_/Q _5172_/S VGND VGND VPWR VPWR _6074_/D sky130_fd_sc_hd__mux2_1
X_4103_ _4101_/B _4101_/C _5571_/Q VGND VGND VPWR VPWR _4124_/C sky130_fd_sc_hd__a21oi_1
X_5083_ hold289/X _5494_/Q _5099_/S VGND VGND VPWR VPWR _6006_/D sky130_fd_sc_hd__mux2_1
XFILLER_56_217 VGND VGND VPWR VPWR sky130_fd_sc_hd__fill_1
XFILLER_37_431 VPWR VGND VPWR VGND sky130_ef_sc_hd__decap_12
X_4034_ hold94/A hold90/A _4052_/S VGND VGND VPWR VPWR _4034_/X sky130_fd_sc_hd__mux2_1
XTAP_TAPCELL_ROW_69_1040 VGND VPWR sky130_fd_sc_hd__tapvpwrvgnd_1
XFILLER_25_615 VGND VGND VPWR VPWR sky130_fd_sc_hd__fill_1
XTAP_TAPCELL_ROW_35_621 VGND VPWR sky130_fd_sc_hd__tapvpwrvgnd_1
XFILLER_37_497 VGND VGND VPWR VPWR sky130_fd_sc_hd__decap_6
XTAP_TAPCELL_ROW_63_963 VGND VPWR sky130_fd_sc_hd__tapvpwrvgnd_1
XFILLER_12_309 VGND VGND VPWR VPWR sky130_fd_sc_hd__fill_1
XFILLER_24_136 VGND VGND VPWR VPWR sky130_fd_sc_hd__decap_4
X_5985_ clkload6/A _5985_/D fanout284/X VGND VGND VPWR VPWR _5985_/Q sky130_fd_sc_hd__dfrtp_1
XFILLER_40_618 VGND VGND VPWR VPWR sky130_fd_sc_hd__fill_1
X_4936_ hold407/X _4951_/A2 _4935_/X VGND VGND VPWR VPWR _5921_/D sky130_fd_sc_hd__a21o_1
X_4867_ _4867_/A _4867_/B VGND VGND VPWR VPWR _4867_/Y sky130_fd_sc_hd__nand2_1
X_3818_ _5807_/Q _5508_/Q _3904_/S VGND VGND VPWR VPWR _3818_/X sky130_fd_sc_hd__mux2_1
X_4798_ _5470_/Q hold304/X _4807_/S VGND VGND VPWR VPWR _5835_/D sky130_fd_sc_hd__mux2_1
XANTENNA_fanout129_X _4805_/S VGND VGND VPWR VPWR sky130_fd_sc_hd__diode_2
X_3749_ _3749_/A _3877_/S VGND VGND VPWR VPWR _4176_/C sky130_fd_sc_hd__nor2_2
XANTENNA__4919__S _4943_/S VGND VGND VPWR VPWR sky130_fd_sc_hd__diode_2
X_5419_ _6171_/Q _5427_/B VGND VGND VPWR VPWR _5430_/B sky130_fd_sc_hd__and2_1
XFILLER_28_431 VPWR VGND VPWR VGND sky130_ef_sc_hd__decap_12
XFILLER_15_169 VGND VGND VPWR VPWR sky130_fd_sc_hd__fill_1
XANTENNA_clkbuf_2_0__f_clk_A clkbuf_0_clk/X VGND VGND VPWR VPWR sky130_fd_sc_hd__diode_2
XANTENNA_clkbuf_leaf_16_clk_A clkbuf_leaf_9_clk/A VGND VGND VPWR VPWR sky130_fd_sc_hd__diode_2
XTAP_TAPCELL_ROW_13_337 VGND VPWR sky130_fd_sc_hd__tapvpwrvgnd_1
XTAP_TAPCELL_ROW_13_348 VGND VPWR sky130_fd_sc_hd__tapvpwrvgnd_1
XFILLER_30_139 VGND VGND VPWR VPWR sky130_fd_sc_hd__fill_1
XFILLER_7_357 VPWR VGND VPWR VGND sky130_ef_sc_hd__decap_12
XANTENNA__4554__B1 _3559_/Y VGND VGND VPWR VPWR sky130_fd_sc_hd__diode_2
XFILLER_61_231 VGND VGND VPWR VPWR sky130_fd_sc_hd__fill_1
X_2982_ _5927_/Q _3144_/B _2980_/Y _5936_/Q _2977_/Y VGND VGND VPWR VPWR _2982_/X
+ sky130_fd_sc_hd__a221o_1
XTAP_TAPCELL_ROW_60_933 VGND VPWR sky130_fd_sc_hd__tapvpwrvgnd_1
X_5770_ _6032_/CLK _5770_/D fanout299/X VGND VGND VPWR VPWR _5770_/Q sky130_fd_sc_hd__dfrtp_1
XFILLER_22_629 VGND VGND VPWR VPWR sky130_fd_sc_hd__decap_8
XANTENNA__4793__A0 _5493_/Q VGND VGND VPWR VPWR sky130_fd_sc_hd__diode_2
X_4721_ hold299/X _4745_/A2 _4720_/X VGND VGND VPWR VPWR _5788_/D sky130_fd_sc_hd__o21a_1
XFILLER_14_191 VGND VGND VPWR VPWR sky130_fd_sc_hd__decap_4
XFILLER_30_640 VGND VGND VPWR VPWR sky130_fd_sc_hd__fill_2
X_4652_ _5955_/Q _4748_/A2 _4684_/B1 _4651_/X VGND VGND VPWR VPWR _4652_/X sky130_fd_sc_hd__a211o_1
X_3603_ _3713_/A _3714_/A _3712_/A _3713_/B VGND VGND VPWR VPWR _3607_/A sky130_fd_sc_hd__or4_1
X_4583_ _5913_/Q _5762_/Q _4623_/S VGND VGND VPWR VPWR _4583_/X sky130_fd_sc_hd__mux2_1
X_3534_ _3537_/A _3534_/B VGND VGND VPWR VPWR _3534_/Y sky130_fd_sc_hd__nand2_1
X_3465_ _6146_/Q _6145_/Q _6148_/Q _6147_/Q VGND VGND VPWR VPWR _3468_/C sky130_fd_sc_hd__or4_1
X_5204_ _5231_/A _5204_/B _5206_/C _5204_/D VGND VGND VPWR VPWR _5204_/X sky130_fd_sc_hd__or4_1
X_3396_ _3396_/A _4544_/A VGND VGND VPWR VPWR _3396_/X sky130_fd_sc_hd__or2_1
X_5135_ hold463/X _3639_/A _5137_/S VGND VGND VPWR VPWR _6058_/D sky130_fd_sc_hd__mux2_1
XFILLER_29_206 VGND VGND VPWR VPWR sky130_fd_sc_hd__fill_1
XANTENNA__3520__B2 _6137_/D VGND VGND VPWR VPWR sky130_fd_sc_hd__diode_2
X_5066_ _5990_/Q _3905_/A _5066_/S VGND VGND VPWR VPWR _5990_/D sky130_fd_sc_hd__mux2_1
X_4017_ _5651_/Q _4019_/C _4016_/Y VGND VGND VPWR VPWR _5651_/D sky130_fd_sc_hd__o21a_1
XFILLER_52_253 VGND VGND VPWR VPWR sky130_fd_sc_hd__fill_1
XFILLER_16_58 VGND VGND VPWR VPWR sky130_fd_sc_hd__decap_6
X_5968_ clkload3/A _5968_/D fanout272/X VGND VGND VPWR VPWR _5968_/Q sky130_fd_sc_hd__dfrtp_1
XANTENNA__4784__A0 _5522_/Q VGND VGND VPWR VPWR sky130_fd_sc_hd__diode_2
X_4919_ _5492_/Q _4602_/X _4943_/S VGND VGND VPWR VPWR _4919_/X sky130_fd_sc_hd__mux2_1
XFILLER_12_139 VGND VGND VPWR VPWR sky130_fd_sc_hd__fill_1
X_5899_ _6032_/CLK _5899_/D fanout291/X VGND VGND VPWR VPWR _5899_/Q sky130_fd_sc_hd__dfrtp_1
XTAP_TAPCELL_ROW_10_307 VGND VPWR sky130_fd_sc_hd__tapvpwrvgnd_1
XFILLER_21_651 VPWR VGND VPWR VGND sky130_ef_sc_hd__decap_12
XFILLER_32_57 VGND VGND VPWR VPWR sky130_fd_sc_hd__fill_2
XFILLER_4_338 VPWR VGND VPWR VGND sky130_ef_sc_hd__decap_12
XFILLER_79_106 VGND VGND VPWR VPWR sky130_fd_sc_hd__fill_1
XFILLER_57_65 VGND VGND VPWR VPWR sky130_fd_sc_hd__decap_3
XANTENNA_fanout61_X _5055_/S VGND VGND VPWR VPWR sky130_fd_sc_hd__diode_2
XTAP_TAPCELL_ROW_18_407 VGND VPWR sky130_fd_sc_hd__tapvpwrvgnd_1
XFILLER_28_261 VGND VGND VPWR VPWR sky130_fd_sc_hd__fill_1
XTAP_TAPCELL_ROW_46_749 VGND VPWR sky130_fd_sc_hd__tapvpwrvgnd_1
XFILLER_3_393 VGND VGND VPWR VPWR sky130_fd_sc_hd__fill_1
X_3250_ _3530_/A _3454_/C VGND VGND VPWR VPWR _4342_/A sky130_fd_sc_hd__or2_1
XFILLER_78_150 VGND VGND VPWR VPWR sky130_fd_sc_hd__decap_6
X_3181_ _5729_/Q _5734_/Q VGND VGND VPWR VPWR _3181_/Y sky130_fd_sc_hd__nand2_1
XFILLER_14_3 VGND VGND VPWR VPWR sky130_fd_sc_hd__decap_4
XTAP_TAPCELL_ROW_66_1010 VGND VPWR sky130_fd_sc_hd__tapvpwrvgnd_1
XFILLER_19_272 VGND VGND VPWR VPWR sky130_fd_sc_hd__fill_1
X_5822_ _6093_/CLK _5822_/D fanout344/X VGND VGND VPWR VPWR _5822_/Q sky130_fd_sc_hd__dfrtp_1
XFILLER_34_253 VPWR VGND VPWR VGND sky130_ef_sc_hd__decap_12
X_5753_ _6142_/CLK _5753_/D fanout325/X VGND VGND VPWR VPWR _5753_/Q sky130_fd_sc_hd__dfrtp_1
XANTENNA__4230__A2 _4167_/Y VGND VGND VPWR VPWR sky130_fd_sc_hd__diode_2
X_4704_ _4226_/S _4703_/X _4702_/X _4704_/C1 VGND VGND VPWR VPWR _4704_/X sky130_fd_sc_hd__a211o_1
XANTENNA__5419__A _6171_/Q VGND VGND VPWR VPWR sky130_fd_sc_hd__diode_2
X_2965_ _6110_/Q _4978_/C VGND VGND VPWR VPWR _2965_/X sky130_fd_sc_hd__and2_2
X_2896_ _6001_/Q _2916_/B _2926_/B1 _5997_/Q _2895_/X VGND VGND VPWR VPWR _2896_/X
+ sky130_fd_sc_hd__a221o_1
X_5684_ _5685_/CLK _5684_/D fanout317/X VGND VGND VPWR VPWR _5684_/Q sky130_fd_sc_hd__dfrtp_1
X_4635_ _5920_/Q _4747_/A2 _4747_/B1 _4634_/X VGND VGND VPWR VPWR _4635_/X sky130_fd_sc_hd__a22o_1
X_4566_ _4686_/A1 _4565_/X _4564_/X _4678_/C1 VGND VGND VPWR VPWR _4566_/X sky130_fd_sc_hd__o211a_1
XANTENNA__5191__B1 _4539_/X VGND VGND VPWR VPWR sky130_fd_sc_hd__diode_2
X_3517_ _6117_/D _3517_/B VGND VGND VPWR VPWR _3521_/B sky130_fd_sc_hd__nand2_1
X_4497_ _4492_/Y _4493_/X _4496_/X VGND VGND VPWR VPWR _4497_/X sky130_fd_sc_hd__o21ba_1
X_3448_ _5586_/Q hold35/X _3451_/S VGND VGND VPWR VPWR _5561_/D sky130_fd_sc_hd__mux2_1
XFILLER_69_150 VGND VGND VPWR VPWR sky130_fd_sc_hd__fill_2
X_6167_ _6176_/CLK _6167_/D fanout285/X VGND VGND VPWR VPWR _6167_/Q sky130_fd_sc_hd__dfrtp_4
X_3379_ hold152/X _3396_/A _4544_/A _3378_/X VGND VGND VPWR VPWR _5507_/D sky130_fd_sc_hd__a22o_1
XFILLER_69_183 VGND VGND VPWR VPWR sky130_fd_sc_hd__fill_1
X_5118_ _6041_/Q _4487_/B _5122_/S VGND VGND VPWR VPWR _6041_/D sky130_fd_sc_hd__mux2_1
XANTENNA__6119__RESET_B fanout313/X VGND VGND VPWR VPWR sky130_fd_sc_hd__diode_2
X_6098_ _6107_/CLK _6098_/D fanout273/X VGND VGND VPWR VPWR _6098_/Q sky130_fd_sc_hd__dfrtp_1
X_5049_ _3623_/A _5973_/Q _5054_/S VGND VGND VPWR VPWR _5973_/D sky130_fd_sc_hd__mux2_1
XFILLER_25_275 VGND VGND VPWR VPWR sky130_fd_sc_hd__decap_3
XTAP_TAPCELL_ROW_43_719 VGND VPWR sky130_fd_sc_hd__tapvpwrvgnd_1
XANTENNA_fanout21_A _4331_/A1 VGND VGND VPWR VPWR sky130_fd_sc_hd__diode_2
XANTENNA__4221__A2 _4167_/Y VGND VGND VPWR VPWR sky130_fd_sc_hd__diode_2
XTAP_TAPCELL_ROW_23_465 VGND VPWR sky130_fd_sc_hd__tapvpwrvgnd_1
XFILLER_4_113 VGND VGND VPWR VPWR sky130_fd_sc_hd__fill_1
XFILLER_0_352 VPWR VGND VPWR VGND sky130_ef_sc_hd__decap_12
XANTENNA__4408__A _4408_/A VGND VGND VPWR VPWR sky130_fd_sc_hd__diode_2
XANTENNA__4996__B1 _5024_/B1 VGND VGND VPWR VPWR sky130_fd_sc_hd__diode_2
XANTENNA__4748__B1 _4243_/S VGND VGND VPWR VPWR sky130_fd_sc_hd__diode_2
XFILLER_31_223 VGND VGND VPWR VPWR sky130_fd_sc_hd__fill_1
XANTENNA__4212__A2 _4167_/Y VGND VGND VPWR VPWR sky130_fd_sc_hd__diode_2
X_2750_ _5972_/Q VGND VGND VPWR VPWR _2750_/Y sky130_fd_sc_hd__inv_2
XFILLER_8_441 VPWR VGND VPWR VGND sky130_ef_sc_hd__decap_12
XFILLER_8_474 VGND VGND VPWR VPWR sky130_fd_sc_hd__fill_2
X_4420_ _4424_/A _4420_/B VGND VGND VPWR VPWR _4444_/C sky130_fd_sc_hd__or2_1
XANTENNA__4920__B1 _4950_/B1 VGND VGND VPWR VPWR sky130_fd_sc_hd__diode_2
X_4351_ _5736_/Q _4475_/B VGND VGND VPWR VPWR _4351_/Y sky130_fd_sc_hd__nand2_1
X_4282_ hold373/X _4281_/X _4312_/S VGND VGND VPWR VPWR _5712_/D sky130_fd_sc_hd__mux2_1
X_3302_ _5397_/A _5982_/Q VGND VGND VPWR VPWR _3364_/A sky130_fd_sc_hd__and2b_1
X_6021_ _6021_/CLK _6021_/D fanout344/X VGND VGND VPWR VPWR _6021_/Q sky130_fd_sc_hd__dfrtp_1
XFILLER_58_109 VGND VGND VPWR VPWR sky130_fd_sc_hd__decap_4
X_3233_ _5637_/Q hold71/X _3238_/S VGND VGND VPWR VPWR _5497_/D sky130_fd_sc_hd__mux2_1
XTAP_TAPCELL_ROW_72_1080 VGND VPWR sky130_fd_sc_hd__tapvpwrvgnd_1
X_3164_ _5949_/Q _3153_/B _3163_/X VGND VGND VPWR VPWR _3164_/X sky130_fd_sc_hd__o21a_1
XFILLER_66_186 VGND VGND VPWR VPWR sky130_fd_sc_hd__fill_1
X_3095_ _4014_/A _3095_/B VGND VGND VPWR VPWR _3095_/Y sky130_fd_sc_hd__nor2_1
XFILLER_66_197 VGND VGND VPWR VPWR sky130_fd_sc_hd__decap_6
XFILLER_35_540 VGND VGND VPWR VPWR sky130_fd_sc_hd__fill_1
XFILLER_23_702 VGND VGND VPWR VPWR sky130_fd_sc_hd__decap_8
Xfanout27 _4176_/X VGND VGND VPWR VPWR _4235_/S sky130_fd_sc_hd__clkbuf_2
XFILLER_62_381 VGND VGND VPWR VPWR sky130_fd_sc_hd__fill_1
Xfanout16 _3759_/S VGND VGND VPWR VPWR _3917_/S sky130_fd_sc_hd__clkbuf_2
Xfanout38 _3724_/X VGND VGND VPWR VPWR _4829_/B sky130_fd_sc_hd__clkbuf_4
XANTENNA__4739__B1 _4747_/B1 VGND VGND VPWR VPWR sky130_fd_sc_hd__diode_2
XANTENNA__4203__A2 _4167_/Y VGND VGND VPWR VPWR sky130_fd_sc_hd__diode_2
XFILLER_13_15 VGND VGND VPWR VPWR sky130_fd_sc_hd__decap_3
X_3997_ _5626_/Q _3997_/B VGND VGND VPWR VPWR _3997_/Y sky130_fd_sc_hd__nand2_1
X_5805_ clkload4/A _5805_/D fanout278/X VGND VGND VPWR VPWR _5805_/Q sky130_fd_sc_hd__dfrtp_1
Xfanout49 _3369_/Y VGND VGND VPWR VPWR _3877_/S sky130_fd_sc_hd__clkbuf_4
X_5736_ clkload8/A _5736_/D fanout285/X VGND VGND VPWR VPWR _5736_/Q sky130_fd_sc_hd__dfrtp_4
XANTENNA_fanout323_A fanout324/X VGND VGND VPWR VPWR sky130_fd_sc_hd__diode_2
X_2948_ _2949_/B _3968_/S _2949_/D VGND VGND VPWR VPWR _2948_/Y sky130_fd_sc_hd__nor3_1
XFILLER_13_59 VGND VGND VPWR VPWR sky130_fd_sc_hd__decap_8
XTAP_TAPCELL_ROW_20_424 VGND VPWR sky130_fd_sc_hd__tapvpwrvgnd_1
XTAP_TAPCELL_ROW_20_435 VGND VPWR sky130_fd_sc_hd__tapvpwrvgnd_1
X_5667_ _6113_/CLK _5667_/D VGND VGND VPWR VPWR hold87/A sky130_fd_sc_hd__dfxtp_1
X_2879_ _6073_/Q _2916_/B _2918_/B1 _6085_/Q VGND VGND VPWR VPWR _2879_/X sky130_fd_sc_hd__a22o_1
X_4618_ _5494_/Q _5800_/Q _4618_/S VGND VGND VPWR VPWR _4618_/X sky130_fd_sc_hd__mux2_1
XANTENNA_fanout111_X _4864_/S VGND VGND VPWR VPWR sky130_fd_sc_hd__diode_2
X_5598_ _5635_/CLK _5598_/D fanout315/X VGND VGND VPWR VPWR _5598_/Q sky130_fd_sc_hd__dfrtp_1
Xhold441 _5925_/Q VGND VGND VPWR VPWR hold441/X sky130_fd_sc_hd__dlygate4sd3_1
XANTENNA__4911__B1 _4950_/B1 VGND VGND VPWR VPWR sky130_fd_sc_hd__diode_2
XANTENNA__4199__S _4226_/S VGND VGND VPWR VPWR sky130_fd_sc_hd__diode_2
Xhold430 _5928_/Q VGND VGND VPWR VPWR hold430/X sky130_fd_sc_hd__dlygate4sd3_1
Xhold463 _6058_/Q VGND VGND VPWR VPWR hold463/X sky130_fd_sc_hd__dlygate4sd3_1
Xhold452 _5987_/Q VGND VGND VPWR VPWR hold452/X sky130_fd_sc_hd__dlygate4sd3_1
X_4549_ _5758_/Q _2837_/B _3746_/X VGND VGND VPWR VPWR _5758_/D sky130_fd_sc_hd__a21o_1
Xhold474 _5946_/Q VGND VGND VPWR VPWR hold474/X sky130_fd_sc_hd__dlygate4sd3_1
XFILLER_58_643 VGND VGND VPWR VPWR sky130_fd_sc_hd__fill_1
XANTENNA_fanout69_A _5109_/S VGND VGND VPWR VPWR sky130_fd_sc_hd__diode_2
XTAP_TAPCELL_ROW_28_524 VGND VPWR sky130_fd_sc_hd__tapvpwrvgnd_1
XTAP_TAPCELL_ROW_28_535 VGND VPWR sky130_fd_sc_hd__tapvpwrvgnd_1
XFILLER_45_337 VGND VGND VPWR VPWR sky130_fd_sc_hd__fill_1
XTAP_TAPCELL_ROW_56_877 VGND VPWR sky130_fd_sc_hd__tapvpwrvgnd_1
XTAP_TAPCELL_ROW_0_171 VGND VPWR sky130_fd_sc_hd__tapvpwrvgnd_1
XTAP_TAPCELL_ROW_0_182 VGND VPWR sky130_fd_sc_hd__tapvpwrvgnd_1
XFILLER_13_223 VGND VGND VPWR VPWR sky130_fd_sc_hd__fill_1
XFILLER_9_216 VGND VGND VPWR VPWR sky130_fd_sc_hd__decap_8
XANTENNA__3402__A0 _5094_/A1 VGND VGND VPWR VPWR sky130_fd_sc_hd__diode_2
XFILLER_70_54 VGND VGND VPWR VPWR sky130_fd_sc_hd__decap_3
Xclkload19 _5792_/CLK VGND VGND VPWR VPWR clkload19/Y sky130_fd_sc_hd__clkinv_8
XANTENNA__4902__B1 _4878_/B VGND VGND VPWR VPWR sky130_fd_sc_hd__diode_2
XFILLER_79_74 VGND VGND VPWR VPWR sky130_fd_sc_hd__fill_1
XFILLER_68_429 VGND VGND VPWR VPWR sky130_fd_sc_hd__fill_1
XANTENNA__2783__A_N _2864_/A VGND VGND VPWR VPWR sky130_fd_sc_hd__diode_2
XTAP_TAPCELL_ROW_8_282 VGND VPWR sky130_fd_sc_hd__tapvpwrvgnd_1
XFILLER_48_153 VGND VGND VPWR VPWR sky130_fd_sc_hd__fill_1
XFILLER_0_193 VGND VGND VPWR VPWR sky130_fd_sc_hd__decap_3
XFILLER_48_175 VGND VGND VPWR VPWR sky130_fd_sc_hd__fill_1
X_3920_ _5583_/Q _3240_/B _3554_/Y _3918_/X VGND VGND VPWR VPWR _5583_/D sky130_fd_sc_hd__a22o_1
XFILLER_44_381 VGND VGND VPWR VPWR sky130_fd_sc_hd__decap_6
X_3851_ _5575_/Q _3759_/S _3848_/Y _3850_/Y VGND VGND VPWR VPWR _5575_/D sky130_fd_sc_hd__o22a_1
X_2802_ _2799_/X _2800_/X _2801_/X _2797_/X VGND VGND VPWR VPWR _2815_/B sky130_fd_sc_hd__o31a_1
X_3782_ _3374_/X _3767_/A _3781_/X _3906_/A2 VGND VGND VPWR VPWR _4098_/B sky130_fd_sc_hd__a22o_1
X_5521_ _6085_/CLK _5521_/D fanout331/X VGND VGND VPWR VPWR _5521_/Q sky130_fd_sc_hd__dfrtp_4
X_2733_ _6160_/Q VGND VGND VPWR VPWR _2733_/Y sky130_fd_sc_hd__inv_2
XANTENNA__3944__A1 _3559_/Y VGND VGND VPWR VPWR sky130_fd_sc_hd__diode_2
X_5452_ _5366_/A _5451_/Y _5447_/Y VGND VGND VPWR VPWR _6175_/D sky130_fd_sc_hd__o21ai_1
X_4403_ _4403_/A _4403_/B VGND VGND VPWR VPWR _4403_/Y sky130_fd_sc_hd__xnor2_1
X_5383_ _6166_/Q _5453_/B VGND VGND VPWR VPWR _5385_/A sky130_fd_sc_hd__and2_1
X_4334_ _2843_/B _5731_/Q _4336_/S VGND VGND VPWR VPWR _5726_/D sky130_fd_sc_hd__mux2_1
Xfanout217 _2831_/A VGND VGND VPWR VPWR _2844_/C sky130_fd_sc_hd__clkbuf_2
Xfanout206 _6111_/Q VGND VGND VPWR VPWR _2871_/B sky130_fd_sc_hd__buf_2
Xfanout228 _5753_/Q VGND VGND VPWR VPWR _4943_/S sky130_fd_sc_hd__buf_4
X_4265_ _4266_/A _4266_/B VGND VGND VPWR VPWR _4265_/X sky130_fd_sc_hd__and2_1
X_6004_ _6088_/CLK _6004_/D fanout338/X VGND VGND VPWR VPWR _6004_/Q sky130_fd_sc_hd__dfrtp_1
Xfanout239 _5746_/Q VGND VGND VPWR VPWR _3626_/A sky130_fd_sc_hd__clkbuf_2
X_4196_ _5905_/Q _5762_/Q _4241_/S VGND VGND VPWR VPWR _4196_/X sky130_fd_sc_hd__mux2_1
X_3216_ hold27/X _5639_/Q _3219_/S VGND VGND VPWR VPWR _5483_/D sky130_fd_sc_hd__mux2_1
X_3147_ _5906_/Q _2987_/Y _3145_/X _3146_/X _2989_/Y VGND VGND VPWR VPWR _3147_/X
+ sky130_fd_sc_hd__o221a_1
XFILLER_27_315 VGND VGND VPWR VPWR sky130_fd_sc_hd__decap_8
XFILLER_27_337 VPWR VGND VPWR VGND sky130_ef_sc_hd__decap_12
X_3078_ _5597_/Q _5683_/Q VGND VGND VPWR VPWR _3081_/B sky130_fd_sc_hd__xor2_1
XTAP_TAPCELL_ROW_53_847 VGND VPWR sky130_fd_sc_hd__tapvpwrvgnd_1
XFILLER_42_329 VGND VGND VPWR VPWR sky130_fd_sc_hd__fill_2
XANTENNA__3935__A1 _3559_/Y VGND VGND VPWR VPWR sky130_fd_sc_hd__diode_2
XTAP_TAPCELL_ROW_33_593 VGND VPWR sky130_fd_sc_hd__tapvpwrvgnd_1
X_5719_ _5788_/CLK _5719_/D fanout297/X VGND VGND VPWR VPWR _5719_/Q sky130_fd_sc_hd__dfrtp_4
XFILLER_2_414 VGND VGND VPWR VPWR sky130_fd_sc_hd__decap_6
Xhold260 _5769_/Q VGND VGND VPWR VPWR hold260/X sky130_fd_sc_hd__dlygate4sd3_1
Xhold271 _5884_/Q VGND VGND VPWR VPWR hold271/X sky130_fd_sc_hd__dlygate4sd3_1
XFILLER_49_11 VGND VGND VPWR VPWR sky130_fd_sc_hd__fill_2
XANTENNA__4360__A1 _6109_/Q VGND VGND VPWR VPWR sky130_fd_sc_hd__diode_2
Xhold282 _5847_/Q VGND VGND VPWR VPWR hold282/X sky130_fd_sc_hd__dlygate4sd3_1
XFILLER_77_204 VGND VGND VPWR VPWR sky130_fd_sc_hd__fill_1
XFILLER_49_55 VGND VGND VPWR VPWR sky130_fd_sc_hd__fill_1
Xhold293 _5509_/Q VGND VGND VPWR VPWR hold293/X sky130_fd_sc_hd__dlygate4sd3_1
XANTENNA__4648__C1 _4704_/C1 VGND VGND VPWR VPWR sky130_fd_sc_hd__diode_2
XFILLER_49_66 VPWR VGND VPWR VGND sky130_ef_sc_hd__decap_12
XTAP_TAPCELL_ROW_5_241 VGND VPWR sky130_fd_sc_hd__tapvpwrvgnd_1
XFILLER_46_613 VGND VGND VPWR VPWR sky130_fd_sc_hd__decap_8
XFILLER_58_495 VGND VGND VPWR VPWR sky130_fd_sc_hd__fill_2
XFILLER_18_359 VGND VGND VPWR VPWR sky130_fd_sc_hd__decap_4
XFILLER_26_370 VGND VGND VPWR VPWR sky130_fd_sc_hd__decap_4
XFILLER_14_587 VGND VGND VPWR VPWR sky130_fd_sc_hd__fill_1
XANTENNA__3926__B2 _3918_/X VGND VGND VPWR VPWR sky130_fd_sc_hd__diode_2
X_4050_ hold85/A hold64/A _4052_/S VGND VGND VPWR VPWR _4051_/B sky130_fd_sc_hd__mux2_1
Xinput6 uio_in[7] VGND VGND VPWR VPWR input6/X sky130_fd_sc_hd__clkbuf_1
X_3001_ _2992_/X _3000_/Y _6137_/Q _2965_/X VGND VGND VPWR VPWR _6137_/D sky130_fd_sc_hd__o2bb2a_1
XFILLER_36_101 VGND VGND VPWR VPWR sky130_fd_sc_hd__fill_2
XFILLER_64_487 VGND VGND VPWR VPWR sky130_fd_sc_hd__decap_4
XFILLER_24_307 VGND VGND VPWR VPWR sky130_fd_sc_hd__fill_1
X_4952_ _2824_/C _4690_/X _4973_/S VGND VGND VPWR VPWR _4952_/X sky130_fd_sc_hd__mux2_1
X_4883_ _5794_/Q _5518_/Q _4901_/S VGND VGND VPWR VPWR _4883_/X sky130_fd_sc_hd__mux2_1
XTAP_TAPCELL_ROW_50_806 VGND VPWR sky130_fd_sc_hd__tapvpwrvgnd_1
X_3903_ _3394_/X _3767_/A _3901_/X _3764_/X VGND VGND VPWR VPWR _3907_/A sky130_fd_sc_hd__a22oi_1
X_3834_ _5573_/Q _5574_/Q _3834_/C VGND VGND VPWR VPWR _3859_/C sky130_fd_sc_hd__and3_1
XFILLER_32_384 VGND VGND VPWR VPWR sky130_fd_sc_hd__fill_1
XTAP_TAPCELL_ROW_80_1190 VGND VPWR sky130_fd_sc_hd__tapvpwrvgnd_1
XTAP_TAPCELL_ROW_30_552 VGND VPWR sky130_fd_sc_hd__tapvpwrvgnd_1
X_3765_ _3725_/A _3725_/C _4175_/D VGND VGND VPWR VPWR _3765_/Y sky130_fd_sc_hd__o21ai_1
XANTENNA__4590__A1 _4686_/A1 VGND VGND VPWR VPWR sky130_fd_sc_hd__diode_2
X_3696_ _4428_/A _6037_/Q _6041_/Q _3656_/A _3648_/B VGND VGND VPWR VPWR _3721_/A
+ sky130_fd_sc_hd__o221ai_2
XANTENNA__5427__A _5427_/A VGND VGND VPWR VPWR sky130_fd_sc_hd__diode_2
XANTENNA__3393__A2 _3396_/A VGND VGND VPWR VPWR sky130_fd_sc_hd__diode_2
X_5504_ _5811_/CLK _5504_/D fanout288/X VGND VGND VPWR VPWR _5504_/Q sky130_fd_sc_hd__dfrtp_1
XANTENNA_fanout119_A _5096_/S VGND VGND VPWR VPWR sky130_fd_sc_hd__diode_2
XFILLER_10_27 VGND VGND VPWR VPWR sky130_fd_sc_hd__fill_1
X_5435_ _6173_/Q _5442_/B VGND VGND VPWR VPWR _5435_/Y sky130_fd_sc_hd__nand2_1
X_5366_ _5366_/A _5366_/B _5366_/C VGND VGND VPWR VPWR _5366_/X sky130_fd_sc_hd__or3_1
X_4317_ _5721_/Q _3734_/Y _4315_/Y _4333_/S VGND VGND VPWR VPWR _4317_/X sky130_fd_sc_hd__a31o_1
X_5297_ _5327_/C _5297_/B _5301_/B VGND VGND VPWR VPWR _5297_/X sky130_fd_sc_hd__and3_1
X_4248_ _5699_/Q _5700_/Q _4093_/A _4256_/C _2776_/A VGND VGND VPWR VPWR _4250_/A
+ sky130_fd_sc_hd__a311oi_4
XTAP_TAPCELL_ROW_58_906 VGND VPWR sky130_fd_sc_hd__tapvpwrvgnd_1
XTAP_TAPCELL_ROW_2_200 VGND VPWR sky130_fd_sc_hd__tapvpwrvgnd_1
XTAP_TAPCELL_ROW_2_211 VGND VPWR sky130_fd_sc_hd__tapvpwrvgnd_1
X_4179_ _4178_/X _4165_/X _4234_/S VGND VGND VPWR VPWR _4179_/X sky130_fd_sc_hd__mux2_1
XFILLER_27_156 VPWR VGND VPWR VGND sky130_ef_sc_hd__decap_12
XTAP_TAPCELL_ROW_38_652 VGND VPWR sky130_fd_sc_hd__tapvpwrvgnd_1
XFILLER_27_189 VGND VGND VPWR VPWR sky130_fd_sc_hd__fill_1
XANTENNA__5101__S _5127_/B VGND VGND VPWR VPWR sky130_fd_sc_hd__diode_2
XFILLER_70_479 VGND VGND VPWR VPWR sky130_fd_sc_hd__fill_1
XANTENNA__4940__S _4943_/S VGND VGND VPWR VPWR sky130_fd_sc_hd__diode_2
XANTENNA__6143__D _6143_/D VGND VGND VPWR VPWR sky130_fd_sc_hd__diode_2
XFILLER_50_170 VGND VGND VPWR VPWR sky130_fd_sc_hd__decap_8
XPHY_EDGE_ROW_14_Right_14 VGND VGND VPWR VPWR sky130_fd_sc_hd__decap_3
XFILLER_23_395 VPWR VGND VPWR VGND sky130_ef_sc_hd__decap_12
XANTENNA__4581__A1 _5762_/Q VGND VGND VPWR VPWR sky130_fd_sc_hd__diode_2
XANTENNA__4884__A2 _4878_/A VGND VGND VPWR VPWR sky130_fd_sc_hd__diode_2
XFILLER_2_288 VPWR VGND VPWR VGND sky130_ef_sc_hd__decap_12
XPHY_EDGE_ROW_23_Right_23 VGND VGND VPWR VPWR sky130_fd_sc_hd__decap_3
XANTENNA__5950__RESET_B fanout334/X VGND VGND VPWR VPWR sky130_fd_sc_hd__diode_2
XANTENNA__4636__A2 _4748_/A2 VGND VGND VPWR VPWR sky130_fd_sc_hd__diode_2
XANTENNA__3304__B _5201_/B VGND VGND VPWR VPWR sky130_fd_sc_hd__diode_2
XFILLER_18_123 VGND VGND VPWR VPWR sky130_fd_sc_hd__decap_8
XFILLER_18_167 VGND VGND VPWR VPWR sky130_fd_sc_hd__fill_1
XPHY_EDGE_ROW_32_Right_32 VGND VGND VPWR VPWR sky130_fd_sc_hd__decap_3
XTAP_TAPCELL_ROW_16_379 VGND VPWR sky130_fd_sc_hd__tapvpwrvgnd_1
XFILLER_14_395 VPWR VGND VPWR VGND sky130_ef_sc_hd__decap_12
XANTENNA__6056__RESET_B fanout283/X VGND VGND VPWR VPWR sky130_fd_sc_hd__diode_2
XANTENNA__3375__A2 _3396_/A VGND VGND VPWR VPWR sky130_fd_sc_hd__diode_2
X_3550_ _3550_/A _3550_/B VGND VGND VPWR VPWR _3550_/Y sky130_fd_sc_hd__xnor2_1
X_5220_ _5223_/B _5220_/B VGND VGND VPWR VPWR _6125_/D sky130_fd_sc_hd__and2_1
X_3481_ _6130_/D _3265_/B _3267_/B _3480_/X VGND VGND VPWR VPWR _3491_/A sky130_fd_sc_hd__o31a_1
XPHY_EDGE_ROW_41_Right_41 VGND VGND VPWR VPWR sky130_fd_sc_hd__decap_3
XFILLER_44_3 VGND VGND VPWR VPWR sky130_fd_sc_hd__decap_4
X_5151_ hold287/X _5489_/Q _5167_/S VGND VGND VPWR VPWR _6073_/D sky130_fd_sc_hd__mux2_1
XANTENNA__4297__S _5458_/C VGND VGND VPWR VPWR sky130_fd_sc_hd__diode_2
X_5082_ hold153/X _5493_/Q _5098_/S VGND VGND VPWR VPWR _6005_/D sky130_fd_sc_hd__mux2_1
X_4102_ _5576_/Q _4102_/B _4102_/C VGND VGND VPWR VPWR _4124_/B sky130_fd_sc_hd__and3_1
XANTENNA__4627__A2 _4747_/A2 VGND VGND VPWR VPWR sky130_fd_sc_hd__diode_2
X_4033_ _4074_/S1 _4033_/B VGND VGND VPWR VPWR _4033_/X sky130_fd_sc_hd__and2b_1
XFILLER_2_83 VGND VGND VPWR VPWR sky130_fd_sc_hd__fill_1
XTAP_TAPCELL_ROW_69_1041 VGND VPWR sky130_fd_sc_hd__tapvpwrvgnd_1
XFILLER_64_240 VPWR VGND VPWR VGND sky130_ef_sc_hd__decap_12
XPHY_EDGE_ROW_50_Right_50 VGND VGND VPWR VPWR sky130_fd_sc_hd__decap_3
XTAP_TAPCELL_ROW_35_622 VGND VPWR sky130_fd_sc_hd__tapvpwrvgnd_1
XTAP_TAPCELL_ROW_63_964 VGND VPWR sky130_fd_sc_hd__tapvpwrvgnd_1
X_5984_ _6110_/CLK _5984_/D fanout300/X VGND VGND VPWR VPWR _5984_/Q sky130_fd_sc_hd__dfrtp_1
X_4935_ _4647_/X _4950_/A2 _4950_/B1 _4934_/X VGND VGND VPWR VPWR _4935_/X sky130_fd_sc_hd__a22o_1
X_4866_ _3728_/X _4865_/Y _4866_/S VGND VGND VPWR VPWR _5899_/D sky130_fd_sc_hd__mux2_1
XANTENNA_fanout236_A _3639_/A VGND VGND VPWR VPWR sky130_fd_sc_hd__diode_2
X_4797_ _5469_/Q hold275/X _4809_/S VGND VGND VPWR VPWR _5834_/D sky130_fd_sc_hd__mux2_1
X_3817_ _5406_/A _3902_/A2 _3816_/X VGND VGND VPWR VPWR _3817_/X sky130_fd_sc_hd__o21a_1
X_3748_ _5066_/S VGND VGND VPWR VPWR _3748_/Y sky130_fd_sc_hd__inv_2
X_3679_ _3719_/A _3719_/B VGND VGND VPWR VPWR _3679_/Y sky130_fd_sc_hd__nand2_1
X_5418_ _6170_/Q _5441_/B _5417_/X VGND VGND VPWR VPWR _6170_/D sky130_fd_sc_hd__a21o_1
X_5349_ _3930_/C _3267_/B _5348_/X _3452_/X VGND VGND VPWR VPWR _5362_/C sky130_fd_sc_hd__o31a_1
XANTENNA__4000__S _4005_/S VGND VGND VPWR VPWR sky130_fd_sc_hd__diode_2
XANTENNA_fanout51_A _4678_/A1 VGND VGND VPWR VPWR sky130_fd_sc_hd__diode_2
XANTENNA__2963__B _2964_/B VGND VGND VPWR VPWR sky130_fd_sc_hd__diode_2
XFILLER_28_498 VGND VGND VPWR VPWR sky130_fd_sc_hd__fill_2
XANTENNA__5043__A2 _5043_/A2 VGND VGND VPWR VPWR sky130_fd_sc_hd__diode_2
XANTENNA__2801__A1 _2895_/A VGND VGND VPWR VPWR sky130_fd_sc_hd__diode_2
XTAP_TAPCELL_ROW_13_338 VGND VPWR sky130_fd_sc_hd__tapvpwrvgnd_1
Xclkbuf_leaf_50_clk clkload0/A VGND VGND VPWR VPWR clkload9/A sky130_fd_sc_hd__clkbuf_8
XFILLER_7_314 VPWR VGND VPWR VGND sky130_ef_sc_hd__decap_12
XFILLER_11_398 VGND VGND VPWR VPWR sky130_fd_sc_hd__fill_2
XANTENNA__4554__A1 _5762_/Q VGND VGND VPWR VPWR sky130_fd_sc_hd__diode_2
XFILLER_78_365 VGND VGND VPWR VPWR sky130_fd_sc_hd__decap_4
XANTENNA__4845__S _4863_/S VGND VGND VPWR VPWR sky130_fd_sc_hd__diode_2
XFILLER_19_432 VGND VGND VPWR VPWR sky130_fd_sc_hd__fill_1
XFILLER_34_413 VGND VGND VPWR VPWR sky130_fd_sc_hd__decap_6
XANTENNA__4242__B1 _4747_/A2 VGND VGND VPWR VPWR sky130_fd_sc_hd__diode_2
X_2981_ _3128_/B _3130_/A _4876_/A VGND VGND VPWR VPWR _2981_/X sky130_fd_sc_hd__or3b_1
X_4720_ _4235_/S _4719_/X _4718_/X _4720_/C1 VGND VGND VPWR VPWR _4720_/X sky130_fd_sc_hd__a211o_1
XTAP_TAPCELL_ROW_60_934 VGND VPWR sky130_fd_sc_hd__tapvpwrvgnd_1
Xclkbuf_leaf_41_clk clkload1/A VGND VGND VPWR VPWR _5685_/CLK sky130_fd_sc_hd__clkbuf_8
X_4651_ _5922_/Q _4684_/A2 _4683_/B1 _4650_/X VGND VGND VPWR VPWR _4651_/X sky130_fd_sc_hd__a22o_1
XANTENNA__3196__S _3203_/S VGND VGND VPWR VPWR sky130_fd_sc_hd__diode_2
X_3602_ _4428_/A _6053_/Q VGND VGND VPWR VPWR _3713_/B sky130_fd_sc_hd__nor2_1
XTAP_TAPCELL_ROW_40_680 VGND VPWR sky130_fd_sc_hd__tapvpwrvgnd_1
X_4582_ _4686_/A1 _4581_/X _4580_/X _4678_/C1 VGND VGND VPWR VPWR _4582_/X sky130_fd_sc_hd__o211a_1
X_3533_ _3563_/C _3563_/D VGND VGND VPWR VPWR _3564_/A sky130_fd_sc_hd__nand2_2
X_3464_ _6150_/Q _6149_/Q _6152_/Q _6151_/Q VGND VGND VPWR VPWR _3468_/B sky130_fd_sc_hd__or4_1
X_5203_ _5203_/A _5203_/B _5203_/C _5203_/D VGND VGND VPWR VPWR _5204_/D sky130_fd_sc_hd__and4_1
X_5134_ hold312/X _4487_/B _5137_/S VGND VGND VPWR VPWR _6057_/D sky130_fd_sc_hd__mux2_1
X_3395_ hold174/X _3396_/A _4544_/A _3394_/X VGND VGND VPWR VPWR _5515_/D sky130_fd_sc_hd__a22o_1
XANTENNA__4608__X _4608_/X VGND VGND VPWR VPWR sky130_fd_sc_hd__diode_2
X_5065_ hold469/X _5447_/A _5123_/B VGND VGND VPWR VPWR _5989_/D sky130_fd_sc_hd__mux2_1
XANTENNA__2783__B _2783_/B VGND VGND VPWR VPWR sky130_fd_sc_hd__diode_2
X_4016_ _5651_/Q _4019_/C hold11/A VGND VGND VPWR VPWR _4016_/Y sky130_fd_sc_hd__a21oi_1
XTAP_TAPCELL_ROW_48_780 VGND VPWR sky130_fd_sc_hd__tapvpwrvgnd_1
XFILLER_25_413 VGND VGND VPWR VPWR sky130_fd_sc_hd__fill_1
XANTENNA__5025__A2 _5025_/A2 VGND VGND VPWR VPWR sky130_fd_sc_hd__diode_2
XANTENNA__4233__B1 _4176_/C VGND VGND VPWR VPWR sky130_fd_sc_hd__diode_2
X_5967_ _5967_/CLK _5967_/D fanout307/X VGND VGND VPWR VPWR _5967_/Q sky130_fd_sc_hd__dfrtp_1
X_4918_ hold395/X _4948_/A2 _4917_/X VGND VGND VPWR VPWR _5915_/D sky130_fd_sc_hd__a21o_1
Xclkbuf_leaf_32_clk clkload2/A VGND VGND VPWR VPWR _6115_/CLK sky130_fd_sc_hd__clkbuf_8
XANTENNA_fanout141_X _5024_/A2 VGND VGND VPWR VPWR sky130_fd_sc_hd__diode_2
XANTENNA_fanout239_X _3626_/A VGND VGND VPWR VPWR sky130_fd_sc_hd__diode_2
XFILLER_40_438 VGND VGND VPWR VPWR sky130_fd_sc_hd__fill_1
X_5898_ _6091_/CLK _5898_/D fanout347/X VGND VGND VPWR VPWR _5898_/Q sky130_fd_sc_hd__dfrtp_1
XFILLER_21_663 VGND VGND VPWR VPWR sky130_fd_sc_hd__decap_8
X_4849_ _5467_/Q hold326/X _4862_/S VGND VGND VPWR VPWR _5883_/D sky130_fd_sc_hd__mux2_1
XTAP_TAPCELL_ROW_10_308 VGND VPWR sky130_fd_sc_hd__tapvpwrvgnd_1
XANTENNA__3642__A_N _4517_/A VGND VGND VPWR VPWR sky130_fd_sc_hd__diode_2
XFILLER_20_195 VGND VGND VPWR VPWR sky130_fd_sc_hd__fill_1
XANTENNA_fanout99_A _5170_/S VGND VGND VPWR VPWR sky130_fd_sc_hd__diode_2
XFILLER_57_77 VGND VGND VPWR VPWR sky130_fd_sc_hd__decap_4
XFILLER_57_55 VGND VGND VPWR VPWR sky130_fd_sc_hd__fill_1
XANTENNA_fanout54_X _4750_/C1 VGND VGND VPWR VPWR sky130_fd_sc_hd__diode_2
XTAP_TAPCELL_ROW_18_408 VGND VPWR sky130_fd_sc_hd__tapvpwrvgnd_1
XFILLER_73_43 VPWR VGND VPWR VGND sky130_ef_sc_hd__decap_12
XFILLER_71_530 VGND VGND VPWR VPWR sky130_fd_sc_hd__fill_1
XANTENNA__5016__A2 _5024_/A2 VGND VGND VPWR VPWR sky130_fd_sc_hd__diode_2
XANTENNA__4224__B1 _4176_/C VGND VGND VPWR VPWR sky130_fd_sc_hd__diode_2
Xclkbuf_leaf_23_clk clkload2/A VGND VGND VPWR VPWR _5952_/CLK sky130_fd_sc_hd__clkbuf_8
XFILLER_12_663 VGND VGND VPWR VPWR sky130_fd_sc_hd__fill_2
XANTENNA__5793__Q _5793_/Q VGND VGND VPWR VPWR sky130_fd_sc_hd__diode_2
XFILLER_7_111 VGND VGND VPWR VPWR sky130_fd_sc_hd__fill_1
XFILLER_7_177 VPWR VGND VPWR VGND sky130_ef_sc_hd__decap_12
XANTENNA__3750__A2 _3746_/X VGND VGND VPWR VPWR sky130_fd_sc_hd__diode_2
XANTENNA__3045__A _5524_/Q VGND VGND VPWR VPWR sky130_fd_sc_hd__diode_2
X_3180_ _5714_/Q _3183_/B _5735_/Q VGND VGND VPWR VPWR uio_oe[6] sky130_fd_sc_hd__and3b_4
XFILLER_78_162 VGND VGND VPWR VPWR sky130_fd_sc_hd__fill_1
XFILLER_39_505 VPWR VGND VPWR VGND sky130_ef_sc_hd__decap_12
XFILLER_19_240 VGND VGND VPWR VPWR sky130_fd_sc_hd__fill_1
XTAP_TAPCELL_ROW_66_1011 VGND VPWR sky130_fd_sc_hd__tapvpwrvgnd_1
XTAP_TAPCELL_ROW_66_1000 VGND VPWR sky130_fd_sc_hd__tapvpwrvgnd_1
XANTENNA__5007__A2 _5027_/A2 VGND VGND VPWR VPWR sky130_fd_sc_hd__diode_2
XANTENNA__4215__B1 _4176_/C VGND VGND VPWR VPWR sky130_fd_sc_hd__diode_2
X_5821_ _6088_/CLK _5821_/D fanout339/X VGND VGND VPWR VPWR _5821_/Q sky130_fd_sc_hd__dfrtp_1
XFILLER_34_265 VGND VGND VPWR VPWR sky130_fd_sc_hd__decap_4
X_5752_ _6113_/CLK _5752_/D VGND VGND VPWR VPWR hold15/A sky130_fd_sc_hd__dfxtp_1
X_2964_ _4175_/A _2964_/B VGND VGND VPWR VPWR _4978_/C sky130_fd_sc_hd__nand2_2
Xclkbuf_leaf_14_clk clkbuf_leaf_9_clk/A VGND VGND VPWR VPWR _5788_/CLK sky130_fd_sc_hd__clkbuf_8
X_4703_ _5761_/Q _5928_/Q _4735_/S VGND VGND VPWR VPWR _4703_/X sky130_fd_sc_hd__mux2_1
X_2895_ _2895_/A _6009_/Q _2895_/C VGND VGND VPWR VPWR _2895_/X sky130_fd_sc_hd__and3_1
X_5683_ _5685_/CLK _5683_/D fanout317/X VGND VGND VPWR VPWR _5683_/Q sky130_fd_sc_hd__dfrtp_1
X_4634_ _5468_/Q _5794_/Q _4682_/S VGND VGND VPWR VPWR _4634_/X sky130_fd_sc_hd__mux2_1
XFILLER_8_93 VPWR VGND VPWR VGND sky130_ef_sc_hd__decap_12
XFILLER_30_493 VPWR VGND VPWR VGND sky130_ef_sc_hd__decap_12
XTAP_TAPCELL_ROW_77_1140 VGND VPWR sky130_fd_sc_hd__tapvpwrvgnd_1
X_4565_ _5944_/Q _5760_/Q _4615_/S VGND VGND VPWR VPWR _4565_/X sky130_fd_sc_hd__mux2_1
XANTENNA__5191__A1 _2871_/C VGND VGND VPWR VPWR sky130_fd_sc_hd__diode_2
XANTENNA__5191__B2 _5736_/Q VGND VGND VPWR VPWR sky130_fd_sc_hd__diode_2
XANTENNA_fanout101_A _5025_/A2 VGND VGND VPWR VPWR sky130_fd_sc_hd__diode_2
X_3516_ _3523_/B _3523_/C _3538_/A VGND VGND VPWR VPWR _3516_/X sky130_fd_sc_hd__a21o_1
XPHY_EDGE_ROW_4_Right_4 VGND VGND VPWR VPWR sky130_fd_sc_hd__decap_3
X_4496_ _4496_/A _4509_/B _4496_/C VGND VGND VPWR VPWR _4496_/X sky130_fd_sc_hd__and3_1
X_3447_ _5585_/Q hold33/X _3451_/S VGND VGND VPWR VPWR _5560_/D sky130_fd_sc_hd__mux2_1
XANTENNA_clkbuf_leaf_15_clk_A clkbuf_leaf_9_clk/A VGND VGND VPWR VPWR sky130_fd_sc_hd__diode_2
X_6166_ _6176_/CLK _6166_/D fanout312/X VGND VGND VPWR VPWR _6166_/Q sky130_fd_sc_hd__dfrtp_1
X_3378_ _5982_/Q _6026_/Q _3394_/S VGND VGND VPWR VPWR _3378_/X sky130_fd_sc_hd__mux2_1
X_5117_ hold369/X _3623_/A _5122_/S VGND VGND VPWR VPWR _6040_/D sky130_fd_sc_hd__mux2_1
X_6097_ _6097_/CLK _6097_/D fanout325/X VGND VGND VPWR VPWR _6097_/Q sky130_fd_sc_hd__dfrtp_1
X_5048_ _2744_/A _5972_/Q _5054_/S VGND VGND VPWR VPWR _5972_/D sky130_fd_sc_hd__mux2_1
XANTENNA_fanout189_X _5427_/A VGND VGND VPWR VPWR sky130_fd_sc_hd__diode_2
XFILLER_53_530 VGND VGND VPWR VPWR sky130_fd_sc_hd__fill_1
XANTENNA__6159__RESET_B fanout283/X VGND VGND VPWR VPWR sky130_fd_sc_hd__diode_2
XFILLER_25_221 VGND VGND VPWR VPWR sky130_fd_sc_hd__decap_3
XANTENNA__4206__B1 _4176_/C VGND VGND VPWR VPWR sky130_fd_sc_hd__diode_2
XANTENNA__4757__A1 _5796_/Q VGND VGND VPWR VPWR sky130_fd_sc_hd__diode_2
XANTENNA__4757__B2 _3548_/Y VGND VGND VPWR VPWR sky130_fd_sc_hd__diode_2
XTAP_TAPCELL_ROW_23_466 VGND VPWR sky130_fd_sc_hd__tapvpwrvgnd_1
XANTENNA__5182__A1 _3626_/A VGND VGND VPWR VPWR sky130_fd_sc_hd__diode_2
XFILLER_5_615 VGND VGND VPWR VPWR sky130_fd_sc_hd__fill_1
X_5462__3 _5966_/CLK VGND VGND VPWR VPWR _5731_/CLK sky130_fd_sc_hd__inv_2
XFILLER_4_29 VPWR VGND VPWR VGND sky130_ef_sc_hd__decap_12
XFILLER_76_600 VGND VGND VPWR VPWR sky130_fd_sc_hd__fill_1
XANTENNA__4693__A0 _5760_/Q VGND VGND VPWR VPWR sky130_fd_sc_hd__diode_2
XANTENNA__4445__B1 _4444_/B VGND VGND VPWR VPWR sky130_fd_sc_hd__diode_2
XANTENNA__3312__B _5427_/A VGND VGND VPWR VPWR sky130_fd_sc_hd__diode_2
XFILLER_8_453 VGND VGND VPWR VPWR sky130_fd_sc_hd__decap_4
X_4350_ _4350_/A _4350_/B _5195_/B VGND VGND VPWR VPWR _4350_/X sky130_fd_sc_hd__or3_1
X_3301_ _5442_/A _5988_/Q VGND VGND VPWR VPWR _3360_/A sky130_fd_sc_hd__nor2_1
X_4281_ _5711_/Q _4266_/Y _4280_/X _4266_/B VGND VGND VPWR VPWR _4281_/X sky130_fd_sc_hd__o22a_1
X_6020_ _6113_/CLK _6020_/D fanout337/X VGND VGND VPWR VPWR _6020_/Q sky130_fd_sc_hd__dfrtp_1
X_3232_ _5636_/Q hold57/X _3238_/S VGND VGND VPWR VPWR _5496_/D sky130_fd_sc_hd__mux2_1
Xclkbuf_leaf_3_clk clkload0/A VGND VGND VPWR VPWR clkload5/A sky130_fd_sc_hd__clkbuf_8
XTAP_TAPCELL_ROW_72_1081 VGND VPWR sky130_fd_sc_hd__tapvpwrvgnd_1
X_3163_ _5957_/Q _2971_/X _2973_/X _5965_/Q _2968_/X VGND VGND VPWR VPWR _3163_/X
+ sky130_fd_sc_hd__a221o_1
XANTENNA__4684__B1 _4684_/B1 VGND VGND VPWR VPWR sky130_fd_sc_hd__diode_2
XANTENNA_clkbuf_2_2__f_clk_X clkload1/A VGND VGND VPWR VPWR sky130_fd_sc_hd__diode_2
X_3094_ _5680_/Q _3097_/C VGND VGND VPWR VPWR _3095_/B sky130_fd_sc_hd__and2_1
Xfanout17 _3736_/X VGND VGND VPWR VPWR _3759_/S sky130_fd_sc_hd__buf_2
Xfanout28 _4176_/X VGND VGND VPWR VPWR _4672_/A1 sky130_fd_sc_hd__clkbuf_4
X_5804_ clkload4/A _5804_/D fanout278/X VGND VGND VPWR VPWR _5804_/Q sky130_fd_sc_hd__dfrtp_1
X_3996_ _3996_/A _3996_/B _3996_/C VGND VGND VPWR VPWR _5625_/D sky130_fd_sc_hd__and3_1
Xfanout39 _3663_/X VGND VGND VPWR VPWR _4436_/S sky130_fd_sc_hd__buf_2
X_5735_ _3182_/A1 _5735_/D fanout295/X VGND VGND VPWR VPWR _5735_/Q sky130_fd_sc_hd__dfrtp_1
XFILLER_13_38 VGND VGND VPWR VPWR sky130_fd_sc_hd__decap_8
XFILLER_10_419 VGND VGND VPWR VPWR sky130_fd_sc_hd__fill_1
X_2947_ _4070_/S _5465_/Q VGND VGND VPWR VPWR _2949_/D sky130_fd_sc_hd__and2b_1
XTAP_TAPCELL_ROW_20_425 VGND VPWR sky130_fd_sc_hd__tapvpwrvgnd_1
XTAP_TAPCELL_ROW_20_436 VGND VPWR sky130_fd_sc_hd__tapvpwrvgnd_1
X_5666_ _6113_/CLK _5666_/D VGND VGND VPWR VPWR hold84/A sky130_fd_sc_hd__dfxtp_1
XANTENNA__5164__A1 _5474_/Q VGND VGND VPWR VPWR sky130_fd_sc_hd__diode_2
X_4617_ hold274/X _4753_/A2 _4616_/X VGND VGND VPWR VPWR _5775_/D sky130_fd_sc_hd__o21a_1
XANTENNA__2789__A _2864_/A VGND VGND VPWR VPWR sky130_fd_sc_hd__diode_2
X_2878_ _5718_/Q _5067_/B _2851_/X _2877_/X _2841_/X VGND VGND VPWR VPWR _6129_/D
+ sky130_fd_sc_hd__a41o_2
Xhold420 _5912_/Q VGND VGND VPWR VPWR hold420/X sky130_fd_sc_hd__dlygate4sd3_1
X_5597_ _5682_/CLK _5597_/D fanout320/X VGND VGND VPWR VPWR _5597_/Q sky130_fd_sc_hd__dfrtp_1
XANTENNA_fanout104_X _5025_/A2 VGND VGND VPWR VPWR sky130_fd_sc_hd__diode_2
Xhold431 _5949_/Q VGND VGND VPWR VPWR hold431/X sky130_fd_sc_hd__dlygate4sd3_1
Xhold453 _5673_/Q VGND VGND VPWR VPWR hold453/X sky130_fd_sc_hd__dlygate4sd3_1
Xhold442 _5605_/Q VGND VGND VPWR VPWR hold442/X sky130_fd_sc_hd__dlygate4sd3_1
X_4548_ _2831_/A _2837_/B _4829_/B _5737_/Q VGND VGND VPWR VPWR _5757_/D sky130_fd_sc_hd__a22o_1
XANTENNA__2922__B1 _2927_/B1 VGND VGND VPWR VPWR sky130_fd_sc_hd__diode_2
Xhold464 _5950_/Q VGND VGND VPWR VPWR hold464/X sky130_fd_sc_hd__dlygate4sd3_1
Xhold475 _5689_/Q VGND VGND VPWR VPWR _3054_/A sky130_fd_sc_hd__dlygate4sd3_1
X_4479_ _4479_/A _4479_/B _4479_/C VGND VGND VPWR VPWR _4482_/B sky130_fd_sc_hd__and3_1
XFILLER_57_110 VGND VGND VPWR VPWR sky130_fd_sc_hd__fill_2
X_6149_ _6149_/CLK _6149_/D fanout310/X VGND VGND VPWR VPWR _6149_/Q sky130_fd_sc_hd__dfrtp_1
XANTENNA__5104__S _5127_/B VGND VGND VPWR VPWR sky130_fd_sc_hd__diode_2
XPHY_EDGE_ROW_79_Right_79 VGND VGND VPWR VPWR sky130_fd_sc_hd__decap_3
XFILLER_72_102 VGND VGND VPWR VPWR sky130_fd_sc_hd__fill_1
XANTENNA__4943__S _4943_/S VGND VGND VPWR VPWR sky130_fd_sc_hd__diode_2
XFILLER_26_530 VGND VGND VPWR VPWR sky130_fd_sc_hd__fill_2
XTAP_TAPCELL_ROW_28_525 VGND VPWR sky130_fd_sc_hd__tapvpwrvgnd_1
XTAP_TAPCELL_ROW_28_536 VGND VPWR sky130_fd_sc_hd__tapvpwrvgnd_1
XTAP_TAPCELL_ROW_56_878 VGND VPWR sky130_fd_sc_hd__tapvpwrvgnd_1
XFILLER_54_45 VGND VGND VPWR VPWR sky130_fd_sc_hd__decap_8
XFILLER_54_34 VGND VGND VPWR VPWR sky130_fd_sc_hd__fill_1
XTAP_TAPCELL_ROW_0_172 VGND VPWR sky130_fd_sc_hd__tapvpwrvgnd_1
XTAP_TAPCELL_ROW_0_183 VGND VPWR sky130_fd_sc_hd__tapvpwrvgnd_1
XANTENNA__5155__A1 _5493_/Q VGND VGND VPWR VPWR sky130_fd_sc_hd__diode_2
XANTENNA__2913__B1 _2918_/B1 VGND VGND VPWR VPWR sky130_fd_sc_hd__diode_2
XFILLER_68_419 VGND VGND VPWR VPWR sky130_fd_sc_hd__fill_1
XANTENNA__4666__A0 _5472_/Q VGND VGND VPWR VPWR sky130_fd_sc_hd__diode_2
XTAP_TAPCELL_ROW_8_283 VGND VPWR sky130_fd_sc_hd__tapvpwrvgnd_1
XFILLER_1_673 VPWR VGND VPWR VGND sky130_ef_sc_hd__decap_12
XFILLER_48_143 VGND VGND VPWR VPWR sky130_fd_sc_hd__fill_1
XFILLER_64_658 VGND VGND VPWR VPWR sky130_fd_sc_hd__fill_1
XFILLER_17_596 VGND VGND VPWR VPWR sky130_fd_sc_hd__fill_2
X_3850_ _3860_/B _3849_/Y _3759_/S VGND VGND VPWR VPWR _3850_/Y sky130_fd_sc_hd__o21ai_1
X_2801_ _2895_/A _5832_/Q _2783_/B _2921_/B1 _5820_/Q VGND VGND VPWR VPWR _2801_/X
+ sky130_fd_sc_hd__a32o_1
XANTENNA__4197__A2 _4177_/C VGND VGND VPWR VPWR sky130_fd_sc_hd__diode_2
X_3781_ _5804_/Q _3904_/S _3780_/X _3906_/A1 VGND VGND VPWR VPWR _3781_/X sky130_fd_sc_hd__o211a_1
XFILLER_74_3 VPWR VGND VPWR VGND sky130_ef_sc_hd__decap_12
X_5520_ _6144_/CLK _5520_/D fanout331/X VGND VGND VPWR VPWR _5520_/Q sky130_fd_sc_hd__dfrtp_4
X_2732_ _6145_/Q VGND VGND VPWR VPWR _5258_/A sky130_fd_sc_hd__inv_2
XANTENNA__5146__A1 _5522_/Q VGND VGND VPWR VPWR sky130_fd_sc_hd__diode_2
XANTENNA__4829__A_N _4408_/A VGND VGND VPWR VPWR sky130_fd_sc_hd__diode_2
X_5451_ _5451_/A _5451_/B VGND VGND VPWR VPWR _5451_/Y sky130_fd_sc_hd__xnor2_1
XTAP_TAPCELL_ROW_74_1110 VGND VPWR sky130_fd_sc_hd__tapvpwrvgnd_1
X_4402_ _4392_/A _4392_/B _4390_/A VGND VGND VPWR VPWR _4403_/B sky130_fd_sc_hd__a21o_1
X_5382_ _5410_/C _5380_/Y _5381_/X _5376_/X VGND VGND VPWR VPWR _6165_/D sky130_fd_sc_hd__a31o_1
X_4333_ _2824_/C _5730_/Q _4333_/S VGND VGND VPWR VPWR _5725_/D sky130_fd_sc_hd__mux2_1
X_4264_ _5702_/Q _4273_/B _4266_/B VGND VGND VPWR VPWR _4264_/X sky130_fd_sc_hd__a21o_1
Xfanout229 _4973_/S VGND VGND VPWR VPWR _4949_/S sky130_fd_sc_hd__clkbuf_4
Xfanout218 _2831_/A VGND VGND VPWR VPWR _2833_/A sky130_fd_sc_hd__buf_1
Xfanout207 _6096_/Q VGND VGND VPWR VPWR _3150_/C sky130_fd_sc_hd__clkbuf_4
X_6003_ _6092_/CLK _6003_/D fanout342/X VGND VGND VPWR VPWR _6003_/Q sky130_fd_sc_hd__dfrtp_1
X_3215_ hold43/X _5638_/Q _3219_/S VGND VGND VPWR VPWR _5482_/D sky130_fd_sc_hd__mux2_1
X_4195_ _5771_/Q _4169_/X _4194_/X _3192_/B VGND VGND VPWR VPWR _4200_/A sky130_fd_sc_hd__o211a_1
XPHY_EDGE_ROW_19_Left_100 VGND VGND VPWR VPWR sky130_fd_sc_hd__decap_3
X_3146_ _5922_/Q _2977_/Y _2988_/B _5914_/Q _3127_/B VGND VGND VPWR VPWR _3146_/X
+ sky130_fd_sc_hd__a221o_1
XANTENNA__4616__X _4616_/X VGND VGND VPWR VPWR sky130_fd_sc_hd__diode_2
X_3077_ _5598_/Q _5684_/Q VGND VGND VPWR VPWR _3081_/A sky130_fd_sc_hd__xor2_1
XFILLER_27_349 VPWR VGND VPWR VGND sky130_ef_sc_hd__decap_12
XFILLER_54_157 VGND VGND VPWR VPWR sky130_fd_sc_hd__fill_1
XTAP_TAPCELL_ROW_53_848 VGND VPWR sky130_fd_sc_hd__tapvpwrvgnd_1
XTAP_TAPCELL_ROW_53_837 VGND VPWR sky130_fd_sc_hd__tapvpwrvgnd_1
XFILLER_24_15 VGND VGND VPWR VPWR sky130_fd_sc_hd__decap_4
XTAP_TAPCELL_ROW_33_594 VGND VPWR sky130_fd_sc_hd__tapvpwrvgnd_1
X_5718_ _6163_/CLK _5718_/D fanout313/X VGND VGND VPWR VPWR _5718_/Q sky130_fd_sc_hd__dfrtp_1
X_3979_ _5619_/Q _5618_/Q _5620_/Q VGND VGND VPWR VPWR _3979_/X sky130_fd_sc_hd__and3_1
XANTENNA__5137__A1 _4522_/C VGND VGND VPWR VPWR sky130_fd_sc_hd__diode_2
X_5649_ _5685_/CLK _5649_/D fanout316/X VGND VGND VPWR VPWR _5649_/Q sky130_fd_sc_hd__dfrtp_1
XANTENNA__3699__A1 _4428_/A VGND VGND VPWR VPWR sky130_fd_sc_hd__diode_2
XANTENNA__4003__S _4005_/S VGND VGND VPWR VPWR sky130_fd_sc_hd__diode_2
Xhold250 _5817_/Q VGND VGND VPWR VPWR hold250/X sky130_fd_sc_hd__dlygate4sd3_1
XANTENNA__4896__B1 _4878_/B VGND VGND VPWR VPWR sky130_fd_sc_hd__diode_2
Xhold261 _5770_/Q VGND VGND VPWR VPWR hold261/X sky130_fd_sc_hd__dlygate4sd3_1
XANTENNA__4360__A2 _5736_/Q VGND VGND VPWR VPWR sky130_fd_sc_hd__diode_2
Xhold272 _5839_/Q VGND VGND VPWR VPWR hold272/X sky130_fd_sc_hd__dlygate4sd3_1
Xhold283 _5889_/Q VGND VGND VPWR VPWR hold283/X sky130_fd_sc_hd__dlygate4sd3_1
Xhold294 _5998_/Q VGND VGND VPWR VPWR hold294/X sky130_fd_sc_hd__dlygate4sd3_1
XFILLER_49_78 VGND VGND VPWR VPWR sky130_fd_sc_hd__decap_4
XANTENNA_fanout81_A _4175_/D VGND VGND VPWR VPWR sky130_fd_sc_hd__diode_2
XTAP_TAPCELL_ROW_5_242 VGND VPWR sky130_fd_sc_hd__tapvpwrvgnd_1
XANTENNA__6174__RESET_B fanout286/X VGND VGND VPWR VPWR sky130_fd_sc_hd__diode_2
XFILLER_60_149 VGND VGND VPWR VPWR sky130_fd_sc_hd__decap_6
XANTENNA__4584__C1 _4704_/C1 VGND VGND VPWR VPWR sky130_fd_sc_hd__diode_2
XANTENNA__3387__B1 _4544_/A VGND VGND VPWR VPWR sky130_fd_sc_hd__diode_2
XANTENNA__3926__A2 _3240_/B VGND VGND VPWR VPWR sky130_fd_sc_hd__diode_2
XFILLER_5_231 VPWR VGND VPWR VGND sky130_ef_sc_hd__decap_12
XANTENNA__4848__S _4864_/S VGND VGND VPWR VPWR sky130_fd_sc_hd__diode_2
XANTENNA__4887__B1 _4878_/B VGND VGND VPWR VPWR sky130_fd_sc_hd__diode_2
X_3000_ _2993_/X _2999_/X _3138_/B VGND VGND VPWR VPWR _3000_/Y sky130_fd_sc_hd__a21oi_1
XFILLER_37_614 VGND VGND VPWR VPWR sky130_fd_sc_hd__fill_2
XANTENNA__3862__A1 _4331_/A1 VGND VGND VPWR VPWR sky130_fd_sc_hd__diode_2
XFILLER_37_669 VGND VGND VPWR VPWR sky130_fd_sc_hd__decap_3
XANTENNA__3199__S _3203_/S VGND VGND VPWR VPWR sky130_fd_sc_hd__diode_2
X_4951_ hold374/X _4951_/A2 _4950_/X VGND VGND VPWR VPWR _5926_/D sky130_fd_sc_hd__a21o_1
X_4882_ hold466/X _4975_/A2 _4881_/X VGND VGND VPWR VPWR _5903_/D sky130_fd_sc_hd__a21o_1
XFILLER_51_138 VGND VGND VPWR VPWR sky130_fd_sc_hd__fill_1
XTAP_TAPCELL_ROW_50_807 VGND VPWR sky130_fd_sc_hd__tapvpwrvgnd_1
XFILLER_17_393 VGND VGND VPWR VPWR sky130_fd_sc_hd__fill_1
X_3902_ _3905_/A _3902_/A2 _3901_/X VGND VGND VPWR VPWR _3902_/X sky130_fd_sc_hd__o21a_1
XFILLER_32_374 VGND VGND VPWR VPWR sky130_fd_sc_hd__decap_4
X_3833_ _3192_/X _4865_/A _3830_/X _3832_/X VGND VGND VPWR VPWR _4127_/C sky130_fd_sc_hd__a31oi_2
XTAP_TAPCELL_ROW_80_1180 VGND VPWR sky130_fd_sc_hd__tapvpwrvgnd_1
XTAP_TAPCELL_ROW_80_1191 VGND VPWR sky130_fd_sc_hd__tapvpwrvgnd_1
XTAP_TAPCELL_ROW_30_553 VGND VPWR sky130_fd_sc_hd__tapvpwrvgnd_1
X_3764_ _3725_/A _3725_/C _3902_/A2 VGND VGND VPWR VPWR _3764_/X sky130_fd_sc_hd__o21a_1
X_3695_ _3720_/A _3720_/C _3720_/D _3648_/A VGND VGND VPWR VPWR _3701_/A sky130_fd_sc_hd__or4b_1
XANTENNA__5119__A1 _3639_/A VGND VGND VPWR VPWR sky130_fd_sc_hd__diode_2
X_5503_ _6050_/CLK _5503_/D fanout290/X VGND VGND VPWR VPWR hold97/A sky130_fd_sc_hd__dfrtp_1
X_5434_ _6173_/Q _5442_/B VGND VGND VPWR VPWR _5434_/X sky130_fd_sc_hd__and2_1
X_5365_ _6162_/Q _5365_/B VGND VGND VPWR VPWR _5366_/C sky130_fd_sc_hd__nor2_1
X_4316_ _4319_/B _4150_/Y _4325_/A _5719_/Q VGND VGND VPWR VPWR _4316_/X sky130_fd_sc_hd__o31a_1
X_5296_ _5296_/A _5296_/B VGND VGND VPWR VPWR _5301_/B sky130_fd_sc_hd__nand2_1
X_4247_ _4247_/A _4247_/B VGND VGND VPWR VPWR _4256_/C sky130_fd_sc_hd__nand2_2
XTAP_TAPCELL_ROW_58_907 VGND VPWR sky130_fd_sc_hd__tapvpwrvgnd_1
XFILLER_19_15 VPWR VGND VPWR VGND sky130_ef_sc_hd__decap_12
X_4178_ _5936_/Q _4177_/C _4176_/C _5903_/Q VGND VGND VPWR VPWR _4178_/X sky130_fd_sc_hd__a22o_1
XTAP_TAPCELL_ROW_2_201 VGND VPWR sky130_fd_sc_hd__tapvpwrvgnd_1
XFILLER_27_102 VGND VGND VPWR VPWR sky130_fd_sc_hd__fill_1
XFILLER_27_113 VGND VGND VPWR VPWR sky130_fd_sc_hd__fill_1
XANTENNA__3853__A1 _3626_/A VGND VGND VPWR VPWR sky130_fd_sc_hd__diode_2
XANTENNA_fanout269_X _4970_/A0 VGND VGND VPWR VPWR sky130_fd_sc_hd__diode_2
X_3129_ _2980_/A _3129_/B _5954_/Q _4876_/A VGND VGND VPWR VPWR _3129_/X sky130_fd_sc_hd__and4b_1
XTAP_TAPCELL_ROW_38_653 VGND VPWR sky130_fd_sc_hd__tapvpwrvgnd_1
XANTENNA__4802__A0 _5474_/Q VGND VGND VPWR VPWR sky130_fd_sc_hd__diode_2
XANTENNA__4566__C1 _4678_/C1 VGND VGND VPWR VPWR sky130_fd_sc_hd__diode_2
XFILLER_51_57 VGND VGND VPWR VPWR sky130_fd_sc_hd__decap_4
XFILLER_4_3 VPWR VGND VPWR VGND sky130_ef_sc_hd__decap_12
XANTENNA__5353__A _5353_/A VGND VGND VPWR VPWR sky130_fd_sc_hd__diode_2
XANTENNA__3279__A_N _5447_/A VGND VGND VPWR VPWR sky130_fd_sc_hd__diode_2
XFILLER_19_625 VGND VGND VPWR VPWR sky130_fd_sc_hd__fill_2
XANTENNA__3844__B2 _3783_/A VGND VGND VPWR VPWR sky130_fd_sc_hd__diode_2
XANTENNA__5046__A0 _4427_/A VGND VGND VPWR VPWR sky130_fd_sc_hd__diode_2
XFILLER_18_146 VGND VGND VPWR VPWR sky130_fd_sc_hd__fill_1
XFILLER_18_157 VGND VGND VPWR VPWR sky130_fd_sc_hd__fill_2
XFILLER_46_477 VPWR VGND VPWR VGND sky130_ef_sc_hd__decap_12
XFILLER_33_105 VGND VGND VPWR VPWR sky130_fd_sc_hd__fill_1
XANTENNA__5796__Q _5796_/Q VGND VGND VPWR VPWR sky130_fd_sc_hd__diode_2
XANTENNA__4572__A2 _4166_/C VGND VGND VPWR VPWR sky130_fd_sc_hd__diode_2
X_3480_ _3930_/C _3480_/B _3928_/A VGND VGND VPWR VPWR _3480_/X sky130_fd_sc_hd__and3b_1
XFILLER_69_503 VGND VGND VPWR VPWR sky130_fd_sc_hd__fill_1
X_5150_ hold175/X _5488_/Q _5166_/S VGND VGND VPWR VPWR _6072_/D sky130_fd_sc_hd__mux2_1
XFILLER_37_3 VPWR VGND VPWR VGND sky130_ef_sc_hd__decap_12
X_4101_ _5571_/Q _4101_/B _4101_/C VGND VGND VPWR VPWR _4124_/A sky130_fd_sc_hd__and3_1
X_5081_ hold297/X _5492_/Q _5096_/S VGND VGND VPWR VPWR _6004_/D sky130_fd_sc_hd__mux2_1
X_4032_ hold45/A hold37/A _4052_/S VGND VGND VPWR VPWR _4033_/B sky130_fd_sc_hd__mux2_1
XTAP_TAPCELL_ROW_69_1042 VGND VPWR sky130_fd_sc_hd__tapvpwrvgnd_1
XFILLER_64_285 VGND VGND VPWR VPWR sky130_fd_sc_hd__fill_1
X_5983_ clkload6/A _5983_/D fanout284/X VGND VGND VPWR VPWR _5983_/Q sky130_fd_sc_hd__dfrtp_1
XTAP_TAPCELL_ROW_35_612 VGND VPWR sky130_fd_sc_hd__tapvpwrvgnd_1
XTAP_TAPCELL_ROW_35_623 VGND VPWR sky130_fd_sc_hd__tapvpwrvgnd_1
XTAP_TAPCELL_ROW_63_965 VGND VPWR sky130_fd_sc_hd__tapvpwrvgnd_1
X_4934_ _5469_/Q _4642_/X _4943_/S VGND VGND VPWR VPWR _4934_/X sky130_fd_sc_hd__mux2_1
XFILLER_24_149 VGND VGND VPWR VPWR sky130_fd_sc_hd__fill_1
X_4865_ _4865_/A _4865_/B VGND VGND VPWR VPWR _4865_/Y sky130_fd_sc_hd__nand2_1
XANTENNA_fanout229_A _4973_/S VGND VGND VPWR VPWR sky130_fd_sc_hd__diode_2
X_4796_ _5468_/Q hold315/X _4810_/S VGND VGND VPWR VPWR _5833_/D sky130_fd_sc_hd__mux2_1
XANTENNA_fanout131_A _4809_/S VGND VGND VPWR VPWR sky130_fd_sc_hd__diode_2
XFILLER_20_355 VGND VGND VPWR VPWR sky130_fd_sc_hd__fill_1
X_3816_ _4447_/B _4762_/C _3815_/X _3845_/B VGND VGND VPWR VPWR _3816_/X sky130_fd_sc_hd__a211o_1
XANTENNA__4563__A2 _4684_/A2 VGND VGND VPWR VPWR sky130_fd_sc_hd__diode_2
X_3747_ _4175_/C _4551_/B _3747_/C VGND VGND VPWR VPWR _3747_/X sky130_fd_sc_hd__and3_1
X_3678_ _4399_/A _5968_/Q _5970_/Q _4428_/A _3632_/C VGND VGND VPWR VPWR _3719_/B
+ sky130_fd_sc_hd__o221a_1
XANTENNA__2797__A _6114_/Q VGND VGND VPWR VPWR sky130_fd_sc_hd__diode_2
X_5417_ _5415_/A _5415_/B _5416_/A _5416_/Y _5410_/C VGND VGND VPWR VPWR _5417_/X
+ sky130_fd_sc_hd__o311a_1
XANTENNA__4720__C1 _4720_/C1 VGND VGND VPWR VPWR sky130_fd_sc_hd__diode_2
X_5348_ _6130_/D _6131_/D VGND VGND VPWR VPWR _5348_/X sky130_fd_sc_hd__or2_1
X_5279_ _5276_/A _5276_/B _5274_/A VGND VGND VPWR VPWR _5287_/B sky130_fd_sc_hd__a21o_1
XANTENNA__4517__A _4517_/A VGND VGND VPWR VPWR sky130_fd_sc_hd__diode_2
XFILLER_71_712 VGND VGND VPWR VPWR sky130_fd_sc_hd__fill_1
XANTENNA__3039__C1 _2977_/Y VGND VGND VPWR VPWR sky130_fd_sc_hd__diode_2
XANTENNA_fanout44_A _4740_/B1 VGND VGND VPWR VPWR sky130_fd_sc_hd__diode_2
XFILLER_16_617 VGND VGND VPWR VPWR sky130_fd_sc_hd__fill_1
XFILLER_31_609 VGND VGND VPWR VPWR sky130_fd_sc_hd__fill_1
XFILLER_43_447 VGND VGND VPWR VPWR sky130_fd_sc_hd__fill_1
XFILLER_70_255 VPWR VGND VPWR VGND sky130_ef_sc_hd__decap_12
XTAP_TAPCELL_ROW_13_339 VGND VPWR sky130_fd_sc_hd__tapvpwrvgnd_1
XANTENNA__5348__A _6130_/D VGND VGND VPWR VPWR sky130_fd_sc_hd__diode_2
XFILLER_7_304 VGND VGND VPWR VPWR sky130_fd_sc_hd__fill_1
XFILLER_7_326 VGND VGND VPWR VPWR sky130_fd_sc_hd__fill_2
XANTENNA__3315__B _5397_/A VGND VGND VPWR VPWR sky130_fd_sc_hd__diode_2
XFILLER_39_709 VGND VGND VPWR VPWR sky130_fd_sc_hd__decap_4
XFILLER_66_517 VGND VGND VPWR VPWR sky130_fd_sc_hd__fill_1
XFILLER_78_399 VGND VGND VPWR VPWR sky130_fd_sc_hd__fill_1
XANTENNA__3817__A1 _5406_/A VGND VGND VPWR VPWR sky130_fd_sc_hd__diode_2
XFILLER_19_444 VGND VGND VPWR VPWR sky130_fd_sc_hd__decap_4
XANTENNA__4427__A _4427_/A VGND VGND VPWR VPWR sky130_fd_sc_hd__diode_2
XFILLER_62_712 VGND VGND VPWR VPWR sky130_fd_sc_hd__fill_1
XANTENNA__3331__A _3905_/A VGND VGND VPWR VPWR sky130_fd_sc_hd__diode_2
XANTENNA__4861__S _4864_/S VGND VGND VPWR VPWR sky130_fd_sc_hd__diode_2
XFILLER_34_458 VPWR VGND VPWR VGND sky130_ef_sc_hd__decap_12
XTAP_TAPCELL_ROW_60_924 VGND VPWR sky130_fd_sc_hd__tapvpwrvgnd_1
X_2980_ _2980_/A _3129_/B _2977_/A VGND VGND VPWR VPWR _2980_/Y sky130_fd_sc_hd__nor3b_4
XFILLER_21_108 VGND VGND VPWR VPWR sky130_fd_sc_hd__decap_4
XFILLER_22_609 VGND VGND VPWR VPWR sky130_fd_sc_hd__decap_6
XTAP_TAPCELL_ROW_60_935 VGND VPWR sky130_fd_sc_hd__tapvpwrvgnd_1
X_4650_ _5470_/Q _5796_/Q _4674_/S VGND VGND VPWR VPWR _4650_/X sky130_fd_sc_hd__mux2_1
XFILLER_30_653 VGND VGND VPWR VPWR sky130_fd_sc_hd__fill_1
X_3601_ _4491_/A _6058_/Q VGND VGND VPWR VPWR _3712_/A sky130_fd_sc_hd__nor2_1
XTAP_TAPCELL_ROW_40_681 VGND VPWR sky130_fd_sc_hd__tapvpwrvgnd_1
X_4581_ _5946_/Q _5762_/Q _4623_/S VGND VGND VPWR VPWR _4581_/X sky130_fd_sc_hd__mux2_1
X_3532_ _3529_/X _3530_/Y _3531_/Y _3248_/B _4350_/A VGND VGND VPWR VPWR _3563_/D
+ sky130_fd_sc_hd__a2111o_1
X_3463_ _6128_/D _6131_/D _6130_/D _6129_/D VGND VGND VPWR VPWR _5247_/A sky130_fd_sc_hd__or4bb_1
XANTENNA__3594__A_N _4408_/A VGND VGND VPWR VPWR sky130_fd_sc_hd__diode_2
X_5202_ _6163_/Q _6162_/Q _5202_/C _6176_/Q VGND VGND VPWR VPWR _5203_/D sky130_fd_sc_hd__and4b_1
XANTENNA__4702__C1 _4750_/C1 VGND VGND VPWR VPWR sky130_fd_sc_hd__diode_2
X_5133_ _6056_/Q _4487_/A _5137_/S VGND VGND VPWR VPWR _6056_/D sky130_fd_sc_hd__mux2_1
X_3394_ _5990_/Q _6034_/Q _3394_/S VGND VGND VPWR VPWR _3394_/X sky130_fd_sc_hd__mux2_1
X_5064_ hold465/X _6174_/Q _5066_/S VGND VGND VPWR VPWR _5988_/D sky130_fd_sc_hd__mux2_1
X_4015_ hold11/X _4015_/B _4019_/C VGND VGND VPWR VPWR _5650_/D sky130_fd_sc_hd__nor3_1
XFILLER_65_561 VGND VGND VPWR VPWR sky130_fd_sc_hd__fill_1
XTAP_TAPCELL_ROW_48_781 VGND VPWR sky130_fd_sc_hd__tapvpwrvgnd_1
XFILLER_16_27 VGND VGND VPWR VPWR sky130_fd_sc_hd__fill_1
XANTENNA_fanout346_A fanout351/X VGND VGND VPWR VPWR sky130_fd_sc_hd__diode_2
X_5966_ _5966_/CLK _5966_/D fanout306/X VGND VGND VPWR VPWR _5966_/Q sky130_fd_sc_hd__dfrtp_1
XANTENNA__4624__X _4624_/X VGND VGND VPWR VPWR sky130_fd_sc_hd__diode_2
X_5897_ _6093_/CLK _5897_/D fanout346/X VGND VGND VPWR VPWR _5897_/Q sky130_fd_sc_hd__dfrtp_1
X_4917_ _4599_/X _4947_/A2 _4947_/B1 _4916_/X VGND VGND VPWR VPWR _4917_/X sky130_fd_sc_hd__a22o_1
XANTENNA__4343__Y _5353_/B VGND VGND VPWR VPWR sky130_fd_sc_hd__diode_2
X_4848_ _5494_/Q hold305/X _4864_/S VGND VGND VPWR VPWR _5882_/D sky130_fd_sc_hd__mux2_1
XTAP_TAPCELL_ROW_10_309 VGND VPWR sky130_fd_sc_hd__tapvpwrvgnd_1
X_4779_ _5517_/Q hold147/X _4805_/S VGND VGND VPWR VPWR _5816_/D sky130_fd_sc_hd__mux2_1
XFILLER_4_307 VGND VGND VPWR VPWR sky130_fd_sc_hd__fill_1
XANTENNA__3462__B_N _6131_/D VGND VGND VPWR VPWR sky130_fd_sc_hd__diode_2
XFILLER_4_329 VGND VGND VPWR VPWR sky130_fd_sc_hd__decap_3
XANTENNA__5107__S _5127_/B VGND VGND VPWR VPWR sky130_fd_sc_hd__diode_2
XFILLER_0_579 VGND VGND VPWR VPWR sky130_fd_sc_hd__decap_8
XFILLER_28_230 VGND VGND VPWR VPWR sky130_fd_sc_hd__decap_8
XANTENNA__5582__RESET_B fanout313/X VGND VGND VPWR VPWR sky130_fd_sc_hd__diode_2
XTAP_TAPCELL_ROW_18_409 VGND VPWR sky130_fd_sc_hd__tapvpwrvgnd_1
XFILLER_73_55 VGND VGND VPWR VPWR sky130_fd_sc_hd__fill_1
XANTENNA_fanout47_X _4720_/C1 VGND VGND VPWR VPWR sky130_fd_sc_hd__diode_2
XFILLER_7_189 VPWR VGND VPWR VGND sky130_ef_sc_hd__decap_12
XFILLER_79_642 VGND VGND VPWR VPWR sky130_fd_sc_hd__fill_1
XANTENNA__4856__S _4864_/S VGND VGND VPWR VPWR sky130_fd_sc_hd__diode_2
XFILLER_39_517 VGND VGND VPWR VPWR sky130_fd_sc_hd__decap_4
XFILLER_66_347 VGND VGND VPWR VPWR sky130_fd_sc_hd__fill_1
XTAP_TAPCELL_ROW_66_1001 VGND VPWR sky130_fd_sc_hd__tapvpwrvgnd_1
XANTENNA__4463__A1 _2744_/A VGND VGND VPWR VPWR sky130_fd_sc_hd__diode_2
XFILLER_62_531 VGND VGND VPWR VPWR sky130_fd_sc_hd__fill_1
X_5820_ _6093_/CLK _5820_/D fanout345/X VGND VGND VPWR VPWR _5820_/Q sky130_fd_sc_hd__dfrtp_1
XTAP_TAPCELL_ROW_45_740 VGND VPWR sky130_fd_sc_hd__tapvpwrvgnd_1
XFILLER_34_299 VGND VGND VPWR VPWR sky130_fd_sc_hd__fill_1
X_5751_ _6131_/CLK _5751_/D fanout335/X VGND VGND VPWR VPWR _5751_/Q sky130_fd_sc_hd__dfrtp_1
X_2963_ _4175_/A _2964_/B VGND VGND VPWR VPWR _2963_/X sky130_fd_sc_hd__and2_1
XFILLER_15_491 VGND VGND VPWR VPWR sky130_fd_sc_hd__fill_2
X_4702_ _4750_/A1 _4701_/X _4700_/X _4750_/C1 VGND VGND VPWR VPWR _4702_/X sky130_fd_sc_hd__o211a_1
X_2894_ _2891_/X _2892_/X _2893_/X _2797_/X VGND VGND VPWR VPWR _2901_/B sky130_fd_sc_hd__o31a_1
X_5682_ _5682_/CLK _5682_/D fanout316/X VGND VGND VPWR VPWR _5682_/Q sky130_fd_sc_hd__dfrtp_1
X_4633_ hold224/X _4745_/A2 _4632_/X VGND VGND VPWR VPWR _5777_/D sky130_fd_sc_hd__o21a_1
XANTENNA__4074__S0 _4052_/S VGND VGND VPWR VPWR sky130_fd_sc_hd__diode_2
X_4564_ _5944_/Q _4683_/A2 _4684_/B1 _4563_/X VGND VGND VPWR VPWR _4564_/X sky130_fd_sc_hd__a211o_1
XANTENNA__3726__B1 _5719_/Q VGND VGND VPWR VPWR sky130_fd_sc_hd__diode_2
XTAP_TAPCELL_ROW_77_1141 VGND VPWR sky130_fd_sc_hd__tapvpwrvgnd_1
X_3515_ _3523_/B _3523_/C _3538_/A VGND VGND VPWR VPWR _3515_/Y sky130_fd_sc_hd__a21oi_1
X_4495_ _4522_/A _4495_/B VGND VGND VPWR VPWR _4496_/C sky130_fd_sc_hd__nand2_1
X_3446_ _5584_/Q hold59/X _3451_/S VGND VGND VPWR VPWR _5559_/D sky130_fd_sc_hd__mux2_1
X_6165_ _6176_/CLK _6165_/D fanout314/X VGND VGND VPWR VPWR _6165_/Q sky130_fd_sc_hd__dfrtp_1
X_3377_ hold149/X _3396_/A _3725_/B _3376_/X VGND VGND VPWR VPWR _5506_/D sky130_fd_sc_hd__a22o_1
X_5116_ hold340/X _4467_/A _5116_/S VGND VGND VPWR VPWR _6039_/D sky130_fd_sc_hd__mux2_1
X_6096_ _6111_/CLK _6096_/D fanout327/X VGND VGND VPWR VPWR _6096_/Q sky130_fd_sc_hd__dfrtp_1
X_5047_ _4447_/B hold377/X _5054_/S VGND VGND VPWR VPWR _5971_/D sky130_fd_sc_hd__mux2_1
XFILLER_26_712 VGND VGND VPWR VPWR sky130_fd_sc_hd__fill_1
X_5949_ _6142_/CLK _5949_/D fanout326/X VGND VGND VPWR VPWR _5949_/Q sky130_fd_sc_hd__dfrtp_1
XTAP_TAPCELL_ROW_23_467 VGND VPWR sky130_fd_sc_hd__tapvpwrvgnd_1
XFILLER_5_649 VGND VGND VPWR VPWR sky130_fd_sc_hd__decap_3
XFILLER_0_321 VGND VGND VPWR VPWR sky130_fd_sc_hd__decap_8
XFILLER_75_111 VGND VGND VPWR VPWR sky130_fd_sc_hd__fill_1
XFILLER_0_365 VPWR VGND VPWR VGND sky130_ef_sc_hd__decap_12
XFILLER_75_133 VGND VGND VPWR VPWR sky130_fd_sc_hd__decap_8
XFILLER_17_712 VGND VGND VPWR VPWR sky130_fd_sc_hd__fill_1
XANTENNA__4996__A2 _5024_/A2 VGND VGND VPWR VPWR sky130_fd_sc_hd__diode_2
XFILLER_16_233 VGND VGND VPWR VPWR sky130_fd_sc_hd__decap_4
XFILLER_29_594 VGND VGND VPWR VPWR sky130_fd_sc_hd__decap_6
XFILLER_44_553 VPWR VGND VPWR VGND sky130_ef_sc_hd__decap_12
XANTENNA__4748__A2 _4748_/A2 VGND VGND VPWR VPWR sky130_fd_sc_hd__diode_2
XFILLER_31_203 VPWR VGND VPWR VGND sky130_ef_sc_hd__decap_12
XFILLER_31_225 VGND VGND VPWR VPWR sky130_fd_sc_hd__fill_2
XTAP_TAPCELL_ROW_42_710 VGND VPWR sky130_fd_sc_hd__tapvpwrvgnd_1
XANTENNA__4920__A2 _4950_/A2 VGND VGND VPWR VPWR sky130_fd_sc_hd__diode_2
X_3300_ _5990_/Q _3905_/A VGND VGND VPWR VPWR _3361_/A sky130_fd_sc_hd__and2b_1
Xtt_um_bfcpu_360 VGND VGND VPWR VPWR tt_um_bfcpu_360/HI uio_out[5] sky130_fd_sc_hd__conb_1
X_4280_ _5704_/Q _4279_/X _4310_/S VGND VGND VPWR VPWR _4280_/X sky130_fd_sc_hd__mux2_1
XANTENNA__2895__A _2895_/A VGND VGND VPWR VPWR sky130_fd_sc_hd__diode_2
X_3231_ _5635_/Q hold73/X _3238_/S VGND VGND VPWR VPWR hold74/A sky130_fd_sc_hd__mux2_1
XTAP_TAPCELL_ROW_72_1082 VGND VPWR sky130_fd_sc_hd__tapvpwrvgnd_1
XFILLER_67_623 VGND VGND VPWR VPWR sky130_fd_sc_hd__fill_1
XFILLER_66_100 VGND VGND VPWR VPWR sky130_fd_sc_hd__decap_4
X_3162_ _6141_/Q _2965_/X _3159_/X _3161_/X VGND VGND VPWR VPWR _6141_/D sky130_fd_sc_hd__o22a_1
X_3093_ _4014_/A _3093_/B _3097_/C VGND VGND VPWR VPWR _5679_/D sky130_fd_sc_hd__nor3_1
Xfanout29 _4176_/X VGND VGND VPWR VPWR _4688_/B2 sky130_fd_sc_hd__clkbuf_2
X_5803_ _5811_/CLK _5803_/D fanout289/X VGND VGND VPWR VPWR _5803_/Q sky130_fd_sc_hd__dfrtp_1
Xfanout18 _3758_/S VGND VGND VPWR VPWR _3773_/A sky130_fd_sc_hd__buf_2
XANTENNA__4739__A2 _5123_/B VGND VGND VPWR VPWR sky130_fd_sc_hd__diode_2
X_3995_ _3997_/B VGND VGND VPWR VPWR _3996_/C sky130_fd_sc_hd__inv_2
X_5734_ _3182_/A1 _5734_/D fanout295/X VGND VGND VPWR VPWR _5734_/Q sky130_fd_sc_hd__dfrtp_1
X_2946_ _5466_/Q _3967_/A VGND VGND VPWR VPWR _3968_/S sky130_fd_sc_hd__xor2_1
X_2877_ _2857_/X _2863_/X _2870_/X _2876_/X _2722_/Y VGND VGND VPWR VPWR _2877_/X
+ sky130_fd_sc_hd__a41o_1
XTAP_TAPCELL_ROW_20_426 VGND VPWR sky130_fd_sc_hd__tapvpwrvgnd_1
X_5665_ _6113_/CLK _5665_/D VGND VGND VPWR VPWR hold83/A sky130_fd_sc_hd__dfxtp_1
X_4616_ _4688_/B2 _4615_/X _4614_/X _4704_/C1 VGND VGND VPWR VPWR _4616_/X sky130_fd_sc_hd__a211o_1
XANTENNA__5446__A _5447_/A VGND VGND VPWR VPWR sky130_fd_sc_hd__diode_2
XANTENNA_fanout309_A input1/X VGND VGND VPWR VPWR sky130_fd_sc_hd__diode_2
Xhold410 _5959_/Q VGND VGND VPWR VPWR hold410/X sky130_fd_sc_hd__dlygate4sd3_1
X_5596_ _5685_/CLK _5596_/D fanout316/X VGND VGND VPWR VPWR _5596_/Q sky130_fd_sc_hd__dfrtp_1
Xhold432 _5919_/Q VGND VGND VPWR VPWR hold432/X sky130_fd_sc_hd__dlygate4sd3_1
Xhold443 _5952_/Q VGND VGND VPWR VPWR hold443/X sky130_fd_sc_hd__dlygate4sd3_1
Xhold421 _5713_/Q VGND VGND VPWR VPWR hold421/X sky130_fd_sc_hd__dlygate4sd3_1
XANTENNA__4911__A2 _4950_/A2 VGND VGND VPWR VPWR sky130_fd_sc_hd__diode_2
Xhold454 _5595_/Q VGND VGND VPWR VPWR hold454/X sky130_fd_sc_hd__dlygate4sd3_1
X_4547_ hold356/X _2837_/B _4829_/B _5736_/Q VGND VGND VPWR VPWR _5756_/D sky130_fd_sc_hd__a22o_1
X_4478_ _4478_/A _4478_/B VGND VGND VPWR VPWR _4482_/A sky130_fd_sc_hd__and2_1
Xhold476 hold87/A VGND VGND VPWR VPWR hold476/X sky130_fd_sc_hd__dlygate4sd3_1
Xhold465 _5988_/Q VGND VGND VPWR VPWR hold465/X sky130_fd_sc_hd__dlygate4sd3_1
X_3429_ hold22/X _5584_/Q _3434_/S VGND VGND VPWR VPWR _5543_/D sky130_fd_sc_hd__mux2_1
X_6148_ _6160_/CLK _6148_/D fanout310/X VGND VGND VPWR VPWR _6148_/Q sky130_fd_sc_hd__dfrtp_1
XANTENNA__3253__X _3254_/A VGND VGND VPWR VPWR sky130_fd_sc_hd__diode_2
XPHY_EDGE_ROW_13_Left_94 VGND VGND VPWR VPWR sky130_fd_sc_hd__decap_3
XFILLER_73_615 VGND VGND VPWR VPWR sky130_fd_sc_hd__fill_1
X_6079_ _6091_/CLK _6079_/D fanout347/X VGND VGND VPWR VPWR _6079_/Q sky130_fd_sc_hd__dfrtp_1
XFILLER_72_136 VGND VGND VPWR VPWR sky130_fd_sc_hd__decap_4
XTAP_TAPCELL_ROW_28_526 VGND VPWR sky130_fd_sc_hd__tapvpwrvgnd_1
XTAP_TAPCELL_ROW_56_879 VGND VPWR sky130_fd_sc_hd__tapvpwrvgnd_1
XTAP_TAPCELL_ROW_0_162 VGND VPWR sky130_fd_sc_hd__tapvpwrvgnd_1
XTAP_TAPCELL_ROW_0_173 VGND VPWR sky130_fd_sc_hd__tapvpwrvgnd_1
XTAP_TAPCELL_ROW_0_184 VGND VPWR sky130_fd_sc_hd__tapvpwrvgnd_1
XANTENNA__4902__A2 _4878_/A VGND VGND VPWR VPWR sky130_fd_sc_hd__diode_2
XFILLER_5_457 VGND VGND VPWR VPWR sky130_fd_sc_hd__fill_2
XFILLER_49_601 VGND VGND VPWR VPWR sky130_fd_sc_hd__decap_4
XTAP_TAPCELL_ROW_8_284 VGND VPWR sky130_fd_sc_hd__tapvpwrvgnd_1
XFILLER_1_685 VPWR VGND VPWR VGND sky130_ef_sc_hd__decap_12
XANTENNA__5799__Q _5799_/Q VGND VGND VPWR VPWR sky130_fd_sc_hd__diode_2
XANTENNA__5091__A1 _5474_/Q VGND VGND VPWR VPWR sky130_fd_sc_hd__diode_2
XFILLER_63_169 VGND VGND VPWR VPWR sky130_fd_sc_hd__decap_4
XFILLER_44_361 VGND VGND VPWR VPWR sky130_fd_sc_hd__decap_3
X_2800_ _5840_/Q _2917_/A2 _2886_/B _5844_/Q VGND VGND VPWR VPWR _2800_/X sky130_fd_sc_hd__a22o_1
X_3780_ _5505_/Q _3913_/B VGND VGND VPWR VPWR _3780_/X sky130_fd_sc_hd__or2_1
XANTENNA_clkbuf_leaf_14_clk_A clkbuf_leaf_9_clk/A VGND VGND VPWR VPWR sky130_fd_sc_hd__diode_2
X_2731_ _6146_/Q VGND VGND VPWR VPWR _5256_/A sky130_fd_sc_hd__inv_2
XFILLER_8_251 VGND VGND VPWR VPWR sky130_fd_sc_hd__fill_1
X_5450_ _5446_/X _5450_/B VGND VGND VPWR VPWR _5451_/B sky130_fd_sc_hd__and2b_1
XFILLER_67_3 VGND VGND VPWR VPWR sky130_fd_sc_hd__decap_4
X_4401_ _4401_/A _4401_/B VGND VGND VPWR VPWR _4403_/A sky130_fd_sc_hd__nor2_1
XANTENNA__4354__A0 _5736_/Q VGND VGND VPWR VPWR sky130_fd_sc_hd__diode_2
XTAP_TAPCELL_ROW_74_1111 VGND VPWR sky130_fd_sc_hd__tapvpwrvgnd_1
XTAP_TAPCELL_ROW_74_1100 VGND VPWR sky130_fd_sc_hd__tapvpwrvgnd_1
XANTENNA_clkbuf_leaf_29_clk_A clkload2/A VGND VGND VPWR VPWR sky130_fd_sc_hd__diode_2
X_5381_ _5381_/A _5381_/B VGND VGND VPWR VPWR _5381_/X sky130_fd_sc_hd__or2_1
X_4332_ _5701_/Q _4266_/A _4136_/X _4331_/X hold368/X VGND VGND VPWR VPWR _5724_/D
+ sky130_fd_sc_hd__o32a_1
XANTENNA__2904__B2 _5493_/Q VGND VGND VPWR VPWR sky130_fd_sc_hd__diode_2
XANTENNA__2904__A1 _4970_/A0 VGND VGND VPWR VPWR sky130_fd_sc_hd__diode_2
X_4263_ _5458_/C _4181_/X _4310_/S _4262_/Y VGND VGND VPWR VPWR _4263_/X sky130_fd_sc_hd__o211a_1
Xfanout208 _6095_/Q VGND VGND VPWR VPWR _3150_/B sky130_fd_sc_hd__clkbuf_4
Xfanout219 _5757_/Q VGND VGND VPWR VPWR _2831_/A sky130_fd_sc_hd__dlymetal6s2s_1
X_6002_ _6094_/CLK _6002_/D fanout349/X VGND VGND VPWR VPWR _6002_/Q sky130_fd_sc_hd__dfrtp_1
X_3214_ hold48/X _5637_/Q _3219_/S VGND VGND VPWR VPWR _5481_/D sky130_fd_sc_hd__mux2_1
X_4194_ _5787_/Q _4167_/Y _4170_/Y _5779_/Q _4168_/Y VGND VGND VPWR VPWR _4194_/X
+ sky130_fd_sc_hd__a221o_1
XFILLER_39_133 VGND VGND VPWR VPWR sky130_fd_sc_hd__fill_1
X_3145_ _5939_/Q _2980_/Y _3142_/X _3143_/X _3144_/X VGND VGND VPWR VPWR _3145_/X
+ sky130_fd_sc_hd__a221o_1
X_3076_ _3065_/Y _3066_/X _3075_/X VGND VGND VPWR VPWR _5672_/D sky130_fd_sc_hd__a21oi_1
XANTENNA__5082__A1 _5493_/Q VGND VGND VPWR VPWR sky130_fd_sc_hd__diode_2
XANTENNA_fanout259_A _5725_/Q VGND VGND VPWR VPWR sky130_fd_sc_hd__diode_2
XANTENNA_fanout161_A _4232_/S VGND VGND VPWR VPWR sky130_fd_sc_hd__diode_2
XTAP_TAPCELL_ROW_53_838 VGND VPWR sky130_fd_sc_hd__tapvpwrvgnd_1
XFILLER_23_523 VGND VGND VPWR VPWR sky130_fd_sc_hd__decap_8
XFILLER_50_331 VGND VGND VPWR VPWR sky130_fd_sc_hd__fill_1
XANTENNA__4632__X _4632_/X VGND VGND VPWR VPWR sky130_fd_sc_hd__diode_2
X_3978_ _3978_/A _3978_/B _3978_/C VGND VGND VPWR VPWR _5619_/D sky130_fd_sc_hd__nor3_1
X_2929_ _2926_/X _2927_/X _2928_/X _2785_/X VGND VGND VPWR VPWR _2930_/D sky130_fd_sc_hd__o31a_1
XANTENNA__4593__B1 _4592_/X VGND VGND VPWR VPWR sky130_fd_sc_hd__diode_2
X_5717_ _5723_/CLK _5717_/D _3183_/B VGND VGND VPWR VPWR _5717_/Q sky130_fd_sc_hd__dfrtp_2
XTAP_TAPCELL_ROW_33_595 VGND VPWR sky130_fd_sc_hd__tapvpwrvgnd_1
XANTENNA__3148__A1 _5490_/Q VGND VGND VPWR VPWR sky130_fd_sc_hd__diode_2
X_5648_ _6088_/CLK hold93/X VGND VGND VPWR VPWR _5648_/Q sky130_fd_sc_hd__dfxtp_1
XANTENNA__3148__B2 _5470_/Q VGND VGND VPWR VPWR sky130_fd_sc_hd__diode_2
X_5579_ _5707_/CLK _5579_/D fanout289/X VGND VGND VPWR VPWR _5579_/Q sky130_fd_sc_hd__dfrtp_1
Xhold240 _5789_/Q VGND VGND VPWR VPWR hold240/X sky130_fd_sc_hd__dlygate4sd3_1
Xhold262 _6003_/Q VGND VGND VPWR VPWR hold262/X sky130_fd_sc_hd__dlygate4sd3_1
Xhold251 _5841_/Q VGND VGND VPWR VPWR hold251/X sky130_fd_sc_hd__dlygate4sd3_1
XANTENNA__4896__B2 _4895_/X VGND VGND VPWR VPWR sky130_fd_sc_hd__diode_2
XFILLER_6_7 VGND VGND VPWR VPWR sky130_fd_sc_hd__fill_1
Xhold284 _5791_/Q VGND VGND VPWR VPWR hold284/X sky130_fd_sc_hd__dlygate4sd3_1
Xhold295 _6001_/Q VGND VGND VPWR VPWR hold295/X sky130_fd_sc_hd__dlygate4sd3_1
Xhold273 _5875_/Q VGND VGND VPWR VPWR hold273/X sky130_fd_sc_hd__dlygate4sd3_1
XANTENNA__4648__B2 _4672_/A1 VGND VGND VPWR VPWR sky130_fd_sc_hd__diode_2
XTAP_TAPCELL_ROW_5_243 VGND VPWR sky130_fd_sc_hd__tapvpwrvgnd_1
XFILLER_18_328 VGND VGND VPWR VPWR sky130_fd_sc_hd__decap_8
XANTENNA__5073__A1 _5522_/Q VGND VGND VPWR VPWR sky130_fd_sc_hd__diode_2
XANTENNA__4820__A1 _3626_/A VGND VGND VPWR VPWR sky130_fd_sc_hd__diode_2
XFILLER_60_139 VGND VGND VPWR VPWR sky130_fd_sc_hd__fill_1
XFILLER_14_589 VGND VGND VPWR VPWR sky130_fd_sc_hd__fill_1
XANTENNA__4336__A0 _2934_/B VGND VGND VPWR VPWR sky130_fd_sc_hd__diode_2
XANTENNA__3139__A1 _4943_/S VGND VGND VPWR VPWR sky130_fd_sc_hd__diode_2
XANTENNA__2997__X _4674_/S VGND VGND VPWR VPWR sky130_fd_sc_hd__diode_2
XFILLER_5_243 VPWR VGND VPWR VGND sky130_ef_sc_hd__decap_12
XANTENNA__2898__B1 _2917_/A2 VGND VGND VPWR VPWR sky130_fd_sc_hd__diode_2
XANTENNA__4887__B2 _4886_/X VGND VGND VPWR VPWR sky130_fd_sc_hd__diode_2
XANTENNA__4639__A1 _5761_/Q VGND VGND VPWR VPWR sky130_fd_sc_hd__diode_2
XANTENNA__4149__B _5458_/C VGND VGND VPWR VPWR sky130_fd_sc_hd__diode_2
XANTENNA__4864__S _4864_/S VGND VGND VPWR VPWR sky130_fd_sc_hd__diode_2
XFILLER_36_169 VGND VGND VPWR VPWR sky130_fd_sc_hd__decap_4
XANTENNA__5064__A1 _6174_/Q VGND VGND VPWR VPWR sky130_fd_sc_hd__diode_2
X_4950_ _4687_/X _4950_/A2 _4950_/B1 _4949_/X VGND VGND VPWR VPWR _4950_/X sky130_fd_sc_hd__a22o_1
XFILLER_51_117 VGND VGND VPWR VPWR sky130_fd_sc_hd__fill_1
X_4881_ _4173_/X _4971_/A2 _4971_/B1 _4880_/X VGND VGND VPWR VPWR _4881_/X sky130_fd_sc_hd__a22o_1
X_3901_ _4536_/A _4762_/C _3900_/X _3905_/B VGND VGND VPWR VPWR _3901_/X sky130_fd_sc_hd__a211o_1
XTAP_TAPCELL_ROW_50_808 VGND VPWR sky130_fd_sc_hd__tapvpwrvgnd_1
XFILLER_32_353 VGND VGND VPWR VPWR sky130_fd_sc_hd__fill_1
X_3832_ _5412_/A _3869_/B _3893_/C VGND VGND VPWR VPWR _3832_/X sky130_fd_sc_hd__and3_1
XTAP_TAPCELL_ROW_80_1181 VGND VPWR sky130_fd_sc_hd__tapvpwrvgnd_1
XTAP_TAPCELL_ROW_80_1192 VGND VPWR sky130_fd_sc_hd__tapvpwrvgnd_1
X_5502_ _5645_/CLK _5502_/D VGND VGND VPWR VPWR hold29/A sky130_fd_sc_hd__dfxtp_1
XTAP_TAPCELL_ROW_30_554 VGND VPWR sky130_fd_sc_hd__tapvpwrvgnd_1
X_3763_ _6046_/Q _4175_/C _3291_/Y VGND VGND VPWR VPWR _3905_/C sky130_fd_sc_hd__a21boi_2
X_3694_ _3694_/A _3694_/B VGND VGND VPWR VPWR _3720_/D sky130_fd_sc_hd__or2_1
X_5433_ _5427_/A _5441_/B _5432_/X VGND VGND VPWR VPWR _6172_/D sky130_fd_sc_hd__a21o_1
XANTENNA__3943__S _5353_/A VGND VGND VPWR VPWR sky130_fd_sc_hd__diode_2
X_5364_ _6162_/Q _5365_/B VGND VGND VPWR VPWR _5366_/B sky130_fd_sc_hd__and2_1
X_4315_ _4315_/A _4315_/B VGND VGND VPWR VPWR _4315_/Y sky130_fd_sc_hd__nand2_1
XANTENNA__2786__C _2871_/C VGND VGND VPWR VPWR sky130_fd_sc_hd__diode_2
X_5295_ _5296_/A _5296_/B VGND VGND VPWR VPWR _5297_/B sky130_fd_sc_hd__or2_1
X_4246_ hold124/X _4245_/X _4246_/S VGND VGND VPWR VPWR _5709_/D sky130_fd_sc_hd__mux2_1
XFILLER_19_27 VPWR VGND VPWR VGND sky130_ef_sc_hd__decap_12
XTAP_TAPCELL_ROW_58_908 VGND VPWR sky130_fd_sc_hd__tapvpwrvgnd_1
X_4177_ _5863_/Q _4876_/A _4177_/C VGND VGND VPWR VPWR _4234_/S sky130_fd_sc_hd__and3_2
XTAP_TAPCELL_ROW_2_202 VGND VPWR sky130_fd_sc_hd__tapvpwrvgnd_1
XFILLER_55_434 VGND VGND VPWR VPWR sky130_fd_sc_hd__fill_1
X_3128_ _4166_/B _3128_/B _3130_/A _5962_/Q VGND VGND VPWR VPWR _3128_/X sky130_fd_sc_hd__and4_1
XANTENNA__3853__A2 _3725_/C VGND VGND VPWR VPWR sky130_fd_sc_hd__diode_2
XTAP_TAPCELL_ROW_38_654 VGND VPWR sky130_fd_sc_hd__tapvpwrvgnd_1
XANTENNA__5055__A1 _5377_/A VGND VGND VPWR VPWR sky130_fd_sc_hd__diode_2
XFILLER_55_489 VGND VGND VPWR VPWR sky130_fd_sc_hd__decap_8
X_3059_ hold96/A hold77/X VGND VGND VPWR VPWR hold78/A sky130_fd_sc_hd__nor2_1
XANTENNA__2813__B1 _2926_/B1 VGND VGND VPWR VPWR sky130_fd_sc_hd__diode_2
XANTENNA__3138__B _3138_/B VGND VGND VPWR VPWR sky130_fd_sc_hd__diode_2
XANTENNA__5353__B _5353_/B VGND VGND VPWR VPWR sky130_fd_sc_hd__diode_2
XANTENNA_fanout77_X _4870_/A1 VGND VGND VPWR VPWR sky130_fd_sc_hd__diode_2
XFILLER_46_489 VGND VGND VPWR VPWR sky130_fd_sc_hd__fill_1
XFILLER_14_320 VGND VGND VPWR VPWR sky130_fd_sc_hd__fill_1
XPHY_EDGE_ROW_38_Left_119 VGND VGND VPWR VPWR sky130_fd_sc_hd__decap_3
XFILLER_42_662 VGND VGND VPWR VPWR sky130_fd_sc_hd__fill_1
XANTENNA__4557__B1 _3541_/Y VGND VGND VPWR VPWR sky130_fd_sc_hd__diode_2
XANTENNA__4859__S _4863_/S VGND VGND VPWR VPWR sky130_fd_sc_hd__diode_2
XPHY_EDGE_ROW_47_Left_128 VGND VGND VPWR VPWR sky130_fd_sc_hd__decap_3
X_5080_ hold262/X _5491_/Q _5097_/S VGND VGND VPWR VPWR _6003_/D sky130_fd_sc_hd__mux2_1
X_4100_ _5573_/Q _4100_/B _4100_/C VGND VGND VPWR VPWR _4119_/B sky130_fd_sc_hd__and3_1
XFILLER_2_41 VPWR VGND VPWR VGND sky130_ef_sc_hd__decap_12
X_4031_ hold450/X _4028_/B _4030_/Y VGND VGND VPWR VPWR _5656_/D sky130_fd_sc_hd__o21a_1
XANTENNA__6065__RESET_B fanout341/X VGND VGND VPWR VPWR sky130_fd_sc_hd__diode_2
XFILLER_2_85 VPWR VGND VPWR VGND sky130_ef_sc_hd__decap_12
XTAP_TAPCELL_ROW_69_1043 VGND VPWR sky130_fd_sc_hd__tapvpwrvgnd_1
XFILLER_64_253 VGND VGND VPWR VPWR sky130_fd_sc_hd__decap_3
XPHY_EDGE_ROW_56_Left_137 VGND VGND VPWR VPWR sky130_fd_sc_hd__decap_3
X_5982_ clkload5/A _5982_/D fanout281/X VGND VGND VPWR VPWR _5982_/Q sky130_fd_sc_hd__dfrtp_1
XTAP_TAPCELL_ROW_35_613 VGND VPWR sky130_fd_sc_hd__tapvpwrvgnd_1
XANTENNA__4796__A0 _5468_/Q VGND VGND VPWR VPWR sky130_fd_sc_hd__diode_2
X_4933_ hold428/X _4951_/A2 _4932_/X VGND VGND VPWR VPWR _5920_/D sky130_fd_sc_hd__a21o_1
XTAP_TAPCELL_ROW_63_966 VGND VPWR sky130_fd_sc_hd__tapvpwrvgnd_1
X_4864_ _4973_/A0 hold162/X _4864_/S VGND VGND VPWR VPWR _5898_/D sky130_fd_sc_hd__mux2_1
XTAP_TAPCELL_ROW_15_370 VGND VPWR sky130_fd_sc_hd__tapvpwrvgnd_1
X_4795_ _5467_/Q hold263/X _4807_/S VGND VGND VPWR VPWR _5832_/D sky130_fd_sc_hd__mux2_1
X_3815_ _3887_/A _5853_/Q VGND VGND VPWR VPWR _3815_/X sky130_fd_sc_hd__and2_1
XANTENNA__4548__B1 _4829_/B VGND VGND VPWR VPWR sky130_fd_sc_hd__diode_2
X_3746_ _3477_/Y _3663_/B _3704_/Y _3663_/A _5738_/Q VGND VGND VPWR VPWR _3746_/X
+ sky130_fd_sc_hd__o2111a_4
XANTENNA__3239__A _3240_/A VGND VGND VPWR VPWR sky130_fd_sc_hd__diode_2
XPHY_EDGE_ROW_65_Left_146 VGND VGND VPWR VPWR sky130_fd_sc_hd__decap_3
X_3677_ _2744_/A _2750_/Y _5974_/Q _3656_/A _3632_/B VGND VGND VPWR VPWR _3719_/A
+ sky130_fd_sc_hd__o221a_1
X_5416_ _5416_/A _5416_/B VGND VGND VPWR VPWR _5416_/Y sky130_fd_sc_hd__nand2_1
X_5347_ hold197/X _5235_/B _3928_/X VGND VGND VPWR VPWR _6161_/D sky130_fd_sc_hd__a21bo_1
X_5278_ _6150_/Q _5285_/B VGND VGND VPWR VPWR _5287_/A sky130_fd_sc_hd__and2_1
X_4229_ _5942_/Q _5766_/Q _4232_/S VGND VGND VPWR VPWR _4229_/X sky130_fd_sc_hd__mux2_1
XPHY_EDGE_ROW_74_Left_155 VGND VGND VPWR VPWR sky130_fd_sc_hd__decap_3
XFILLER_15_106 VGND VGND VPWR VPWR sky130_fd_sc_hd__decap_6
XANTENNA__4787__A0 _5487_/Q VGND VGND VPWR VPWR sky130_fd_sc_hd__diode_2
XFILLER_70_267 VGND VGND VPWR VPWR sky130_fd_sc_hd__decap_3
XANTENNA_fanout37_A _4829_/B VGND VGND VPWR VPWR sky130_fd_sc_hd__diode_2
XANTENNA__2801__A3 _2783_/B VGND VGND VPWR VPWR sky130_fd_sc_hd__diode_2
XFILLER_23_194 VGND VGND VPWR VPWR sky130_fd_sc_hd__fill_1
XANTENNA__5348__B _6131_/D VGND VGND VPWR VPWR sky130_fd_sc_hd__diode_2
XANTENNA__3762__A1 _5377_/A VGND VGND VPWR VPWR sky130_fd_sc_hd__diode_2
XANTENNA__4711__A0 _5762_/Q VGND VGND VPWR VPWR sky130_fd_sc_hd__diode_2
XFILLER_19_423 VGND VGND VPWR VPWR sky130_fd_sc_hd__fill_1
XANTENNA__4427__B _4475_/B VGND VGND VPWR VPWR sky130_fd_sc_hd__diode_2
XPHY_EDGE_ROW_1_Left_82 VGND VGND VPWR VPWR sky130_fd_sc_hd__decap_3
XANTENNA__4242__A2 _4748_/A2 VGND VGND VPWR VPWR sky130_fd_sc_hd__diode_2
XFILLER_15_673 VGND VGND VPWR VPWR sky130_fd_sc_hd__decap_4
XTAP_TAPCELL_ROW_60_936 VGND VPWR sky130_fd_sc_hd__tapvpwrvgnd_1
XTAP_TAPCELL_ROW_60_925 VGND VPWR sky130_fd_sc_hd__tapvpwrvgnd_1
XANTENNA__3202__A0 _4970_/A0 VGND VGND VPWR VPWR sky130_fd_sc_hd__diode_2
X_4580_ _5946_/Q _4683_/A2 _4684_/B1 _4579_/X VGND VGND VPWR VPWR _4580_/X sky130_fd_sc_hd__a211o_1
X_3600_ _4424_/A _6052_/Q VGND VGND VPWR VPWR _3714_/A sky130_fd_sc_hd__and2b_1
X_3531_ _3501_/X _3528_/B _3528_/C _3530_/Y _3500_/X VGND VGND VPWR VPWR _3531_/Y
+ sky130_fd_sc_hd__a311oi_1
XTAP_TAPCELL_ROW_40_682 VGND VPWR sky130_fd_sc_hd__tapvpwrvgnd_1
XANTENNA__4950__B1 _4950_/B1 VGND VGND VPWR VPWR sky130_fd_sc_hd__diode_2
X_3462_ _6128_/D _6131_/D _6130_/D _6129_/D VGND VGND VPWR VPWR _3462_/X sky130_fd_sc_hd__and4bb_1
X_5201_ _5427_/A _5201_/B _6174_/Q _5447_/A VGND VGND VPWR VPWR _5202_/C sky130_fd_sc_hd__and4_1
X_3393_ hold209/X _3396_/A _3725_/B _3392_/X VGND VGND VPWR VPWR _5514_/D sky130_fd_sc_hd__a22o_1
X_5132_ hold311/X _4467_/A _5137_/S VGND VGND VPWR VPWR _6055_/D sky130_fd_sc_hd__mux2_1
XFILLER_69_356 VPWR VGND VPWR VGND sky130_ef_sc_hd__decap_12
X_5063_ hold452/X _5201_/B _5066_/S VGND VGND VPWR VPWR _5987_/D sky130_fd_sc_hd__mux2_1
X_4014_ _4014_/A _5649_/Q _5650_/Q VGND VGND VPWR VPWR _4019_/C sky130_fd_sc_hd__and3_1
XFILLER_37_231 VGND VGND VPWR VPWR sky130_fd_sc_hd__fill_1
XTAP_TAPCELL_ROW_48_782 VGND VPWR sky130_fd_sc_hd__tapvpwrvgnd_1
XANTENNA__4233__A2 _4177_/C VGND VGND VPWR VPWR sky130_fd_sc_hd__diode_2
X_5965_ _5965_/CLK _5965_/D fanout303/X VGND VGND VPWR VPWR _5965_/Q sky130_fd_sc_hd__dfrtp_1
XFILLER_12_109 VPWR VGND VPWR VGND sky130_ef_sc_hd__decap_12
XFILLER_80_587 VGND VGND VPWR VPWR sky130_fd_sc_hd__fill_1
X_4916_ _5491_/Q _4594_/X _4949_/S VGND VGND VPWR VPWR _4916_/X sky130_fd_sc_hd__mux2_1
XANTENNA_fanout339_A fanout341/X VGND VGND VPWR VPWR sky130_fd_sc_hd__diode_2
X_5896_ _6113_/CLK _5896_/D fanout337/X VGND VGND VPWR VPWR _5896_/Q sky130_fd_sc_hd__dfrtp_1
X_4847_ _5493_/Q hold265/X _4855_/S VGND VGND VPWR VPWR _5881_/D sky130_fd_sc_hd__mux2_1
XANTENNA__2795__A2 _2783_/B VGND VGND VPWR VPWR sky130_fd_sc_hd__diode_2
XFILLER_32_38 VGND VGND VPWR VPWR sky130_fd_sc_hd__fill_2
XFILLER_21_687 VGND VGND VPWR VPWR sky130_fd_sc_hd__fill_1
XANTENNA__5194__B1 _4539_/X VGND VGND VPWR VPWR sky130_fd_sc_hd__diode_2
XANTENNA_fanout127_X _4950_/B1 VGND VGND VPWR VPWR sky130_fd_sc_hd__diode_2
X_4778_ _5768_/Q _5759_/Q _5758_/Q _5067_/B VGND VGND VPWR VPWR _4778_/Y sky130_fd_sc_hd__nand4_1
XFILLER_20_197 VGND VGND VPWR VPWR sky130_fd_sc_hd__decap_4
X_3729_ _4109_/C _4865_/B VGND VGND VPWR VPWR _3731_/B sky130_fd_sc_hd__and2_1
XFILLER_0_503 VGND VGND VPWR VPWR sky130_fd_sc_hd__fill_1
XFILLER_0_525 VGND VGND VPWR VPWR sky130_fd_sc_hd__decap_6
XANTENNA_input1_X input1/X VGND VGND VPWR VPWR sky130_fd_sc_hd__diode_2
XFILLER_0_558 VGND VGND VPWR VPWR sky130_fd_sc_hd__fill_2
XFILLER_28_253 VGND VGND VPWR VPWR sky130_fd_sc_hd__decap_8
XANTENNA__4224__A2 _4177_/C VGND VGND VPWR VPWR sky130_fd_sc_hd__diode_2
XFILLER_43_245 VGND VGND VPWR VPWR sky130_fd_sc_hd__decap_4
XFILLER_24_470 VGND VGND VPWR VPWR sky130_fd_sc_hd__decap_6
XFILLER_31_418 VPWR VGND VPWR VGND sky130_ef_sc_hd__decap_12
XFILLER_12_632 VPWR VGND VPWR VGND sky130_ef_sc_hd__decap_12
XFILLER_11_164 VGND VGND VPWR VPWR sky130_fd_sc_hd__decap_4
XFILLER_7_113 VGND VGND VPWR VPWR sky130_fd_sc_hd__fill_1
XANTENNA__4932__B1 _4950_/B1 VGND VGND VPWR VPWR sky130_fd_sc_hd__diode_2
XANTENNA__4202__S _4232_/S VGND VGND VPWR VPWR sky130_fd_sc_hd__diode_2
XANTENNA__4696__C1 _4720_/C1 VGND VGND VPWR VPWR sky130_fd_sc_hd__diode_2
XFILLER_78_131 VGND VGND VPWR VPWR sky130_fd_sc_hd__decap_8
XANTENNA__4438__A _4444_/B VGND VGND VPWR VPWR sky130_fd_sc_hd__diode_2
XTAP_TAPCELL_ROW_66_1002 VGND VPWR sky130_fd_sc_hd__tapvpwrvgnd_1
XANTENNA__3120__C1 _2977_/Y VGND VGND VPWR VPWR sky130_fd_sc_hd__diode_2
XFILLER_34_223 VPWR VGND VPWR VGND sky130_ef_sc_hd__decap_12
XANTENNA__4215__A2 _4177_/C VGND VGND VPWR VPWR sky130_fd_sc_hd__diode_2
XFILLER_22_407 VGND VGND VPWR VPWR sky130_fd_sc_hd__decap_6
XTAP_TAPCELL_ROW_45_741 VGND VPWR sky130_fd_sc_hd__tapvpwrvgnd_1
X_5750_ clkload3/A _5750_/D fanout274/X VGND VGND VPWR VPWR _5750_/Q sky130_fd_sc_hd__dfrtp_4
X_2962_ hold222/X _2961_/X _3114_/S VGND VGND VPWR VPWR _6116_/D sky130_fd_sc_hd__mux2_1
X_5681_ _5686_/CLK _5681_/D fanout321/X VGND VGND VPWR VPWR _5681_/Q sky130_fd_sc_hd__dfrtp_1
X_4701_ _5761_/Q _5961_/Q _4735_/S VGND VGND VPWR VPWR _4701_/X sky130_fd_sc_hd__mux2_1
X_4632_ _4628_/X _4630_/X _4631_/X _4672_/A1 _4720_/C1 VGND VGND VPWR VPWR _4632_/X
+ sky130_fd_sc_hd__a221o_1
X_2893_ _2895_/A _5834_/Q _2895_/C _2890_/X VGND VGND VPWR VPWR _2893_/X sky130_fd_sc_hd__a31o_1
XFILLER_30_473 VGND VGND VPWR VPWR sky130_fd_sc_hd__decap_3
X_4563_ _5911_/Q _4684_/A2 _4683_/B1 _4562_/X VGND VGND VPWR VPWR _4563_/X sky130_fd_sc_hd__a22o_1
XANTENNA__4923__B1 _4950_/B1 VGND VGND VPWR VPWR sky130_fd_sc_hd__diode_2
XTAP_TAPCELL_ROW_77_1142 VGND VPWR sky130_fd_sc_hd__tapvpwrvgnd_1
X_4494_ _4522_/A _4495_/B VGND VGND VPWR VPWR _4509_/B sky130_fd_sc_hd__or2_1
X_3514_ _3141_/A _3141_/B _3492_/X VGND VGND VPWR VPWR _3523_/C sky130_fd_sc_hd__a21bo_1
X_3445_ _5583_/Q hold80/X _3451_/S VGND VGND VPWR VPWR _5558_/D sky130_fd_sc_hd__mux2_1
X_3376_ _5981_/Q _6025_/Q _3394_/S VGND VGND VPWR VPWR _3376_/X sky130_fd_sc_hd__mux2_1
X_6164_ _6176_/CLK _6164_/D fanout312/X VGND VGND VPWR VPWR _6164_/Q sky130_fd_sc_hd__dfrtp_1
X_5115_ hold318/X _4444_/B _5122_/S VGND VGND VPWR VPWR _6038_/D sky130_fd_sc_hd__mux2_1
X_6095_ _6111_/CLK _6095_/D fanout327/X VGND VGND VPWR VPWR _6095_/Q sky130_fd_sc_hd__dfrtp_1
XANTENNA_fanout289_A fanout292/X VGND VGND VPWR VPWR sky130_fd_sc_hd__diode_2
X_5046_ _4427_/A _5970_/Q _5054_/S VGND VGND VPWR VPWR _5970_/D sky130_fd_sc_hd__mux2_1
XFILLER_72_307 VGND VGND VPWR VPWR sky130_fd_sc_hd__fill_1
XANTENNA__4782__S _4805_/S VGND VGND VPWR VPWR sky130_fd_sc_hd__diode_2
XANTENNA__4206__A2 _4177_/C VGND VGND VPWR VPWR sky130_fd_sc_hd__diode_2
XFILLER_13_407 VGND VGND VPWR VPWR sky130_fd_sc_hd__fill_1
X_5948_ _5952_/CLK _5948_/D fanout330/X VGND VGND VPWR VPWR _5948_/Q sky130_fd_sc_hd__dfrtp_1
XANTENNA_fanout244_X _4444_/B VGND VGND VPWR VPWR sky130_fd_sc_hd__diode_2
X_5879_ _6092_/CLK _5879_/D fanout342/X VGND VGND VPWR VPWR _5879_/Q sky130_fd_sc_hd__dfrtp_1
XTAP_TAPCELL_ROW_23_468 VGND VPWR sky130_fd_sc_hd__tapvpwrvgnd_1
XANTENNA__4914__B1 _4950_/B1 VGND VGND VPWR VPWR sky130_fd_sc_hd__diode_2
XANTENNA__2940__A2 _5524_/Q VGND VGND VPWR VPWR sky130_fd_sc_hd__diode_2
XANTENNA__4678__C1 _4678_/C1 VGND VGND VPWR VPWR sky130_fd_sc_hd__diode_2
XFILLER_0_377 VPWR VGND VPWR VGND sky130_ef_sc_hd__decap_12
XFILLER_75_156 VGND VGND VPWR VPWR sky130_fd_sc_hd__fill_1
XFILLER_16_245 VGND VGND VPWR VPWR sky130_fd_sc_hd__fill_1
XFILLER_44_565 VGND VGND VPWR VPWR sky130_fd_sc_hd__decap_3
XANTENNA__3405__A0 _4967_/A0 VGND VGND VPWR VPWR sky130_fd_sc_hd__diode_2
XFILLER_31_215 VGND VGND VPWR VPWR sky130_fd_sc_hd__decap_8
XTAP_TAPCELL_ROW_42_700 VGND VPWR sky130_fd_sc_hd__tapvpwrvgnd_1
XTAP_TAPCELL_ROW_42_711 VGND VPWR sky130_fd_sc_hd__tapvpwrvgnd_1
XFILLER_8_400 VGND VGND VPWR VPWR sky130_fd_sc_hd__fill_2
Xtt_um_bfcpu_361 VGND VGND VPWR VPWR tt_um_bfcpu_361/HI uio_out[6] sky130_fd_sc_hd__conb_1
XANTENNA__4133__A1 _4331_/A1 VGND VGND VPWR VPWR sky130_fd_sc_hd__diode_2
X_3230_ _5612_/Q _3408_/B _3958_/B VGND VGND VPWR VPWR _3238_/S sky130_fd_sc_hd__or3b_4
XTAP_TAPCELL_ROW_72_1083 VGND VPWR sky130_fd_sc_hd__tapvpwrvgnd_1
X_3161_ _2993_/X _3160_/X _3138_/B VGND VGND VPWR VPWR _3161_/X sky130_fd_sc_hd__a21o_1
XANTENNA__4684__A2 _4684_/A2 VGND VGND VPWR VPWR sky130_fd_sc_hd__diode_2
XFILLER_12_3 VPWR VGND VPWR VGND sky130_ef_sc_hd__decap_12
XFILLER_39_337 VGND VGND VPWR VPWR sky130_fd_sc_hd__decap_4
XFILLER_39_348 VPWR VGND VPWR VGND sky130_ef_sc_hd__decap_12
XFILLER_66_167 VGND VGND VPWR VPWR sky130_fd_sc_hd__fill_1
X_3092_ _5677_/Q _5678_/Q _5679_/Q VGND VGND VPWR VPWR _3097_/C sky130_fd_sc_hd__and3_1
XFILLER_47_381 VGND VGND VPWR VPWR sky130_fd_sc_hd__fill_1
Xfanout19 _4164_/A VGND VGND VPWR VPWR _3758_/S sky130_fd_sc_hd__buf_2
X_5802_ _6050_/CLK _5802_/D fanout290/X VGND VGND VPWR VPWR _5802_/Q sky130_fd_sc_hd__dfrtp_1
X_3994_ _5624_/Q _5623_/Q _5625_/Q _4005_/S VGND VGND VPWR VPWR _3997_/B sky130_fd_sc_hd__and4_1
XANTENNA__3947__A1 _3541_/Y VGND VGND VPWR VPWR sky130_fd_sc_hd__diode_2
X_5733_ _5733_/CLK _5733_/D fanout305/X VGND VGND VPWR VPWR _5733_/Q sky130_fd_sc_hd__dfrtp_1
X_2945_ _5465_/Q _4070_/S VGND VGND VPWR VPWR _2949_/B sky130_fd_sc_hd__and2b_1
XANTENNA__3946__S _5353_/A VGND VGND VPWR VPWR sky130_fd_sc_hd__diode_2
X_2876_ _6064_/Q _2783_/X _2875_/X _6115_/Q _6114_/Q VGND VGND VPWR VPWR _2876_/X
+ sky130_fd_sc_hd__a2111o_1
XTAP_TAPCELL_ROW_20_427 VGND VPWR sky130_fd_sc_hd__tapvpwrvgnd_1
X_5664_ _6113_/CLK _5664_/D VGND VGND VPWR VPWR _5664_/Q sky130_fd_sc_hd__dfxtp_1
X_4615_ _5917_/Q _5766_/Q _4615_/S VGND VGND VPWR VPWR _4615_/X sky130_fd_sc_hd__mux2_1
X_5595_ _5682_/CLK _5595_/D fanout320/X VGND VGND VPWR VPWR _5595_/Q sky130_fd_sc_hd__dfrtp_1
Xhold400 _5954_/Q VGND VGND VPWR VPWR hold400/X sky130_fd_sc_hd__dlygate4sd3_1
Xhold411 _6029_/Q VGND VGND VPWR VPWR hold411/X sky130_fd_sc_hd__dlygate4sd3_1
X_4546_ _2831_/B _2837_/B _4829_/B _6109_/Q VGND VGND VPWR VPWR _5755_/D sky130_fd_sc_hd__a22o_1
Xhold444 _5906_/Q VGND VGND VPWR VPWR hold444/X sky130_fd_sc_hd__dlygate4sd3_1
Xhold433 _6108_/Q VGND VGND VPWR VPWR hold433/X sky130_fd_sc_hd__dlygate4sd3_1
Xhold422 _6026_/Q VGND VGND VPWR VPWR hold422/X sky130_fd_sc_hd__dlygate4sd3_1
Xhold466 _5903_/Q VGND VGND VPWR VPWR hold466/X sky130_fd_sc_hd__dlygate4sd3_1
X_4477_ _4487_/B _4530_/B VGND VGND VPWR VPWR _4478_/B sky130_fd_sc_hd__or2_1
Xhold477 hold77/A VGND VGND VPWR VPWR _4078_/A sky130_fd_sc_hd__dlygate4sd3_1
Xhold455 _5606_/Q VGND VGND VPWR VPWR hold455/X sky130_fd_sc_hd__dlygate4sd3_1
X_3428_ hold34/X _5583_/Q _3434_/S VGND VGND VPWR VPWR _5542_/D sky130_fd_sc_hd__mux2_1
XANTENNA__4675__A2 _4747_/A2 VGND VGND VPWR VPWR sky130_fd_sc_hd__diode_2
X_6147_ _6160_/CLK _6147_/D fanout310/X VGND VGND VPWR VPWR _6147_/Q sky130_fd_sc_hd__dfrtp_1
X_3359_ _3359_/A _3359_/B _3359_/C VGND VGND VPWR VPWR _3368_/B sky130_fd_sc_hd__or3_1
XFILLER_38_26 VGND VGND VPWR VPWR sky130_fd_sc_hd__fill_2
XANTENNA_fanout194_X _5377_/A VGND VGND VPWR VPWR sky130_fd_sc_hd__diode_2
X_6078_ _6094_/CLK _6078_/D fanout349/X VGND VGND VPWR VPWR _6078_/Q sky130_fd_sc_hd__dfrtp_1
XFILLER_57_145 VGND VGND VPWR VPWR sky130_fd_sc_hd__decap_6
X_5029_ _5960_/Q _5041_/A2 _5028_/X VGND VGND VPWR VPWR _5960_/D sky130_fd_sc_hd__a21o_1
XTAP_TAPCELL_ROW_28_527 VGND VPWR sky130_fd_sc_hd__tapvpwrvgnd_1
XFILLER_72_159 VGND VGND VPWR VPWR sky130_fd_sc_hd__fill_1
XTAP_TAPCELL_ROW_0_163 VGND VPWR sky130_fd_sc_hd__tapvpwrvgnd_1
XTAP_TAPCELL_ROW_0_174 VGND VPWR sky130_fd_sc_hd__tapvpwrvgnd_1
XTAP_TAPCELL_ROW_0_185 VGND VPWR sky130_fd_sc_hd__tapvpwrvgnd_1
XFILLER_13_215 VGND VGND VPWR VPWR sky130_fd_sc_hd__decap_8
XANTENNA__3938__A1 _3541_/Y VGND VGND VPWR VPWR sky130_fd_sc_hd__diode_2
XANTENNA__5208__A_N _6131_/D VGND VGND VPWR VPWR sky130_fd_sc_hd__diode_2
XFILLER_70_46 VGND VGND VPWR VPWR sky130_fd_sc_hd__decap_8
XFILLER_5_447 VGND VGND VPWR VPWR sky130_fd_sc_hd__fill_1
XANTENNA__4687__S _4687_/S VGND VGND VPWR VPWR sky130_fd_sc_hd__diode_2
XANTENNA__2913__A2 _2916_/B VGND VGND VPWR VPWR sky130_fd_sc_hd__diode_2
XANTENNA__2996__A _4746_/S VGND VGND VPWR VPWR sky130_fd_sc_hd__diode_2
XFILLER_1_620 VPWR VGND VPWR VGND sky130_ef_sc_hd__decap_12
XTAP_TAPCELL_ROW_8_285 VGND VPWR sky130_fd_sc_hd__tapvpwrvgnd_1
XTAP_TAPCELL_ROW_8_274 VGND VPWR sky130_fd_sc_hd__tapvpwrvgnd_1
XFILLER_0_163 VGND VGND VPWR VPWR sky130_fd_sc_hd__decap_4
XFILLER_0_141 VGND VGND VPWR VPWR sky130_fd_sc_hd__fill_2
XFILLER_1_697 VPWR VGND VPWR VGND sky130_ef_sc_hd__decap_12
XFILLER_64_616 VGND VGND VPWR VPWR sky130_fd_sc_hd__fill_1
XFILLER_36_329 VGND VGND VPWR VPWR sky130_fd_sc_hd__fill_2
XFILLER_44_91 VGND VGND VPWR VPWR sky130_fd_sc_hd__fill_1
X_2730_ _3530_/A VGND VGND VPWR VPWR _3565_/A sky130_fd_sc_hd__inv_2
X_4400_ _4404_/A _4439_/B VGND VGND VPWR VPWR _4401_/B sky130_fd_sc_hd__nor2_1
XTAP_TAPCELL_ROW_74_1101 VGND VPWR sky130_fd_sc_hd__tapvpwrvgnd_1
X_5380_ _5381_/A _5381_/B VGND VGND VPWR VPWR _5380_/Y sky130_fd_sc_hd__nand2_1
X_4331_ _4331_/A1 _4137_/Y _4325_/B _4330_/Y VGND VGND VPWR VPWR _4331_/X sky130_fd_sc_hd__a31o_1
X_4262_ _5458_/C _4262_/B VGND VGND VPWR VPWR _4262_/Y sky130_fd_sc_hd__nand2_1
Xfanout209 _2977_/A VGND VGND VPWR VPWR _4876_/A sky130_fd_sc_hd__buf_2
X_6001_ _6085_/CLK _6001_/D fanout334/X VGND VGND VPWR VPWR _6001_/Q sky130_fd_sc_hd__dfrtp_1
X_3213_ hold44/X _5636_/Q _3219_/S VGND VGND VPWR VPWR _5480_/D sky130_fd_sc_hd__mux2_1
X_4193_ _5938_/Q _5762_/Q _4241_/S VGND VGND VPWR VPWR _4193_/X sky130_fd_sc_hd__mux2_1
X_3144_ _5930_/Q _3144_/B VGND VGND VPWR VPWR _3144_/X sky130_fd_sc_hd__and2_1
XFILLER_39_167 VGND VGND VPWR VPWR sky130_fd_sc_hd__fill_1
X_3075_ _3075_/A _3075_/B _3075_/C _3075_/D VGND VGND VPWR VPWR _3075_/X sky130_fd_sc_hd__or4_1
XFILLER_27_329 VGND VGND VPWR VPWR sky130_fd_sc_hd__decap_6
XFILLER_35_340 VGND VGND VPWR VPWR sky130_fd_sc_hd__fill_1
XTAP_TAPCELL_ROW_53_839 VGND VPWR sky130_fd_sc_hd__tapvpwrvgnd_1
XFILLER_23_513 VGND VGND VPWR VPWR sky130_fd_sc_hd__fill_1
XANTENNA_fanout154_A _3240_/A VGND VGND VPWR VPWR sky130_fd_sc_hd__diode_2
XFILLER_11_708 VGND VGND VPWR VPWR sky130_fd_sc_hd__decap_4
X_3977_ _5619_/Q _5618_/Q _3977_/C VGND VGND VPWR VPWR _3978_/C sky130_fd_sc_hd__and3_1
X_2928_ _6002_/Q _2928_/A2 _2789_/X _6022_/Q VGND VGND VPWR VPWR _2928_/X sky130_fd_sc_hd__a22o_1
X_5716_ _5723_/CLK _5716_/D fanout293/X VGND VGND VPWR VPWR _5716_/Q sky130_fd_sc_hd__dfrtp_4
XFILLER_10_218 VGND VGND VPWR VPWR sky130_fd_sc_hd__decap_3
XANTENNA__4361__A _6109_/Q VGND VGND VPWR VPWR sky130_fd_sc_hd__diode_2
XTAP_TAPCELL_ROW_33_596 VGND VPWR sky130_fd_sc_hd__tapvpwrvgnd_1
XFILLER_40_27 VGND VGND VPWR VPWR sky130_fd_sc_hd__fill_1
X_2859_ _2864_/A _2871_/B _2871_/C _5896_/Q VGND VGND VPWR VPWR _2859_/X sky130_fd_sc_hd__and4_1
X_5647_ _5690_/CLK _5647_/D fanout317/X VGND VGND VPWR VPWR _5647_/Q sky130_fd_sc_hd__dfrtp_1
X_5578_ _5707_/CLK _5578_/D fanout289/X VGND VGND VPWR VPWR _5578_/Q sky130_fd_sc_hd__dfrtp_2
Xhold252 _6014_/Q VGND VGND VPWR VPWR hold252/X sky130_fd_sc_hd__dlygate4sd3_1
Xhold230 _5708_/Q VGND VGND VPWR VPWR hold230/X sky130_fd_sc_hd__dlygate4sd3_1
Xhold241 _6015_/Q VGND VGND VPWR VPWR hold241/X sky130_fd_sc_hd__dlygate4sd3_1
XANTENNA__4896__A2 _4878_/A VGND VGND VPWR VPWR sky130_fd_sc_hd__diode_2
X_4529_ _4520_/A _4517_/Y _4519_/B VGND VGND VPWR VPWR _4531_/A sky130_fd_sc_hd__o21a_1
Xhold263 _5832_/Q VGND VGND VPWR VPWR hold263/X sky130_fd_sc_hd__dlygate4sd3_1
Xhold274 _5775_/Q VGND VGND VPWR VPWR hold274/X sky130_fd_sc_hd__dlygate4sd3_1
Xhold296 _5878_/Q VGND VGND VPWR VPWR hold296/X sky130_fd_sc_hd__dlygate4sd3_1
Xhold285 _5867_/Q VGND VGND VPWR VPWR hold285/X sky130_fd_sc_hd__dlygate4sd3_1
XTAP_TAPCELL_ROW_5_244 VGND VPWR sky130_fd_sc_hd__tapvpwrvgnd_1
XFILLER_65_57 VGND VGND VPWR VPWR sky130_fd_sc_hd__decap_4
XFILLER_58_487 VGND VGND VPWR VPWR sky130_fd_sc_hd__decap_8
XANTENNA__4970__S _4973_/S VGND VGND VPWR VPWR sky130_fd_sc_hd__diode_2
XFILLER_14_535 VGND VGND VPWR VPWR sky130_fd_sc_hd__decap_8
XANTENNA_clkbuf_2_3__f_clk_A clkbuf_0_clk/X VGND VGND VPWR VPWR sky130_fd_sc_hd__diode_2
XANTENNA_fanout22_X _4331_/A1 VGND VGND VPWR VPWR sky130_fd_sc_hd__diode_2
XANTENNA__4584__A1 _4672_/A1 VGND VGND VPWR VPWR sky130_fd_sc_hd__diode_2
XFILLER_14_61 VGND VGND VPWR VPWR sky130_fd_sc_hd__fill_1
XFILLER_6_701 VPWR VGND VPWR VGND sky130_ef_sc_hd__decap_12
XFILLER_5_255 VPWR VGND VPWR VGND sky130_ef_sc_hd__decap_12
XANTENNA__4887__A2 _4878_/A VGND VGND VPWR VPWR sky130_fd_sc_hd__diode_2
XANTENNA__3615__A _4452_/A VGND VGND VPWR VPWR sky130_fd_sc_hd__diode_2
XFILLER_1_461 VGND VGND VPWR VPWR sky130_fd_sc_hd__fill_2
XFILLER_39_80 VGND VGND VPWR VPWR sky130_fd_sc_hd__fill_1
XFILLER_45_660 VGND VGND VPWR VPWR sky130_fd_sc_hd__decap_4
X_4880_ _5793_/Q _5517_/Q _4901_/S VGND VGND VPWR VPWR _4880_/X sky130_fd_sc_hd__mux2_1
X_3900_ _3900_/A _5860_/Q VGND VGND VPWR VPWR _3900_/X sky130_fd_sc_hd__and2_1
XFILLER_32_321 VPWR VGND VPWR VGND sky130_ef_sc_hd__decap_12
XTAP_TAPCELL_ROW_50_809 VGND VPWR sky130_fd_sc_hd__tapvpwrvgnd_1
X_3831_ _3382_/X _3766_/Y _3828_/Y _3765_/Y VGND VGND VPWR VPWR _4127_/B sky130_fd_sc_hd__o2bb2a_1
XANTENNA__4575__A1 _5761_/Q VGND VGND VPWR VPWR sky130_fd_sc_hd__diode_2
X_3762_ _5377_/A _3902_/A2 _3761_/X VGND VGND VPWR VPWR _3762_/X sky130_fd_sc_hd__o21a_1
XTAP_TAPCELL_ROW_80_1193 VGND VPWR sky130_fd_sc_hd__tapvpwrvgnd_1
XTAP_TAPCELL_ROW_80_1182 VGND VPWR sky130_fd_sc_hd__tapvpwrvgnd_1
X_5501_ _6149_/CLK _5501_/D VGND VGND VPWR VPWR hold39/A sky130_fd_sc_hd__dfxtp_1
XTAP_TAPCELL_ROW_30_555 VGND VPWR sky130_fd_sc_hd__tapvpwrvgnd_1
X_3693_ _3693_/A _3693_/B _3693_/C _3688_/Y VGND VGND VPWR VPWR _3693_/X sky130_fd_sc_hd__or4b_1
X_5432_ _5428_/X _5429_/X _5430_/X _5431_/Y _5410_/C VGND VGND VPWR VPWR _5432_/X
+ sky130_fd_sc_hd__o311a_1
X_5363_ _5361_/X _5363_/B VGND VGND VPWR VPWR _5365_/B sky130_fd_sc_hd__and2b_1
X_4314_ _5721_/Q _4329_/B _4315_/B VGND VGND VPWR VPWR _4325_/A sky130_fd_sc_hd__a21oi_1
X_5294_ _5288_/A _5289_/A _5288_/B _5286_/A VGND VGND VPWR VPWR _5296_/B sky130_fd_sc_hd__a31o_1
X_4245_ _4226_/S _4240_/X _4244_/X _4239_/X VGND VGND VPWR VPWR _4245_/X sky130_fd_sc_hd__a211o_1
XTAP_TAPCELL_ROW_58_909 VGND VPWR sky130_fd_sc_hd__tapvpwrvgnd_1
XTAP_TAPCELL_ROW_2_203 VGND VPWR sky130_fd_sc_hd__tapvpwrvgnd_1
XFILLER_19_39 VGND VGND VPWR VPWR sky130_fd_sc_hd__decap_4
XFILLER_28_605 VGND VGND VPWR VPWR sky130_fd_sc_hd__fill_2
X_4176_ _5863_/Q _4977_/A _4176_/C VGND VGND VPWR VPWR _4176_/X sky130_fd_sc_hd__and3_1
XANTENNA_fanout271_A _5475_/Q VGND VGND VPWR VPWR sky130_fd_sc_hd__diode_2
X_3127_ _5905_/Q _3127_/B VGND VGND VPWR VPWR _3127_/Y sky130_fd_sc_hd__nand2_1
XANTENNA__4356__A _5353_/B VGND VGND VPWR VPWR sky130_fd_sc_hd__diode_2
XFILLER_28_638 VGND VGND VPWR VPWR sky130_fd_sc_hd__decap_3
XTAP_TAPCELL_ROW_38_655 VGND VPWR sky130_fd_sc_hd__tapvpwrvgnd_1
X_3058_ _5624_/Q _5625_/Q _5626_/Q _5623_/Q VGND VGND VPWR VPWR _5644_/D sky130_fd_sc_hd__and4bb_1
XFILLER_43_619 VGND VGND VPWR VPWR sky130_fd_sc_hd__fill_1
XANTENNA__4566__A1 _4686_/A1 VGND VGND VPWR VPWR sky130_fd_sc_hd__diode_2
XANTENNA__5187__A _6109_/Q VGND VGND VPWR VPWR sky130_fd_sc_hd__diode_2
XFILLER_50_195 VGND VGND VPWR VPWR sky130_fd_sc_hd__fill_1
XANTENNA__4522__C _4522_/C VGND VGND VPWR VPWR sky130_fd_sc_hd__diode_2
XANTENNA_fanout324_X fanout324/X VGND VGND VPWR VPWR sky130_fd_sc_hd__diode_2
XANTENNA__4318__B2 _5719_/Q VGND VGND VPWR VPWR sky130_fd_sc_hd__diode_2
XANTENNA_clkbuf_leaf_13_clk_A clkbuf_leaf_9_clk/A VGND VGND VPWR VPWR sky130_fd_sc_hd__diode_2
XFILLER_76_67 VPWR VGND VPWR VGND sky130_ef_sc_hd__decap_12
XFILLER_27_671 VGND VGND VPWR VPWR sky130_fd_sc_hd__fill_1
XANTENNA_clkbuf_leaf_28_clk_A clkload2/A VGND VGND VPWR VPWR sky130_fd_sc_hd__diode_2
XFILLER_61_449 VGND VGND VPWR VPWR sky130_fd_sc_hd__fill_1
XFILLER_54_490 VGND VGND VPWR VPWR sky130_fd_sc_hd__decap_3
Xclkbuf_leaf_53_clk clkload0/A VGND VGND VPWR VPWR _6106_/CLK sky130_fd_sc_hd__clkbuf_8
XFILLER_14_365 VGND VGND VPWR VPWR sky130_fd_sc_hd__decap_3
XANTENNA__4205__S _4232_/S VGND VGND VPWR VPWR sky130_fd_sc_hd__diode_2
XANTENNA__4557__A1 _5765_/Q VGND VGND VPWR VPWR sky130_fd_sc_hd__diode_2
XFILLER_6_542 VGND VGND VPWR VPWR sky130_fd_sc_hd__fill_1
XFILLER_6_531 VGND VGND VPWR VPWR sky130_fd_sc_hd__fill_1
XPHY_EDGE_ROW_10_Right_10 VGND VGND VPWR VPWR sky130_fd_sc_hd__decap_3
XFILLER_2_53 VPWR VGND VPWR VGND sky130_ef_sc_hd__decap_12
X_4030_ _5656_/Q _4028_/B hold11/A VGND VGND VPWR VPWR _4030_/Y sky130_fd_sc_hd__a21oi_1
XFILLER_77_571 VGND VGND VPWR VPWR sky130_fd_sc_hd__fill_1
XTAP_TAPCELL_ROW_69_1044 VGND VPWR sky130_fd_sc_hd__tapvpwrvgnd_1
XFILLER_2_97 VGND VGND VPWR VPWR sky130_fd_sc_hd__decap_6
XFILLER_37_446 VGND VGND VPWR VPWR sky130_fd_sc_hd__fill_2
X_5981_ clkload4/A _5981_/D fanout281/X VGND VGND VPWR VPWR _5981_/Q sky130_fd_sc_hd__dfrtp_1
XTAP_TAPCELL_ROW_35_614 VGND VPWR sky130_fd_sc_hd__tapvpwrvgnd_1
X_4932_ _4639_/X _4950_/A2 _4950_/B1 _4931_/X VGND VGND VPWR VPWR _4932_/X sky130_fd_sc_hd__a22o_1
Xclkbuf_leaf_44_clk clkload1/A VGND VGND VPWR VPWR _5635_/CLK sky130_fd_sc_hd__clkbuf_8
XTAP_TAPCELL_ROW_63_967 VGND VPWR sky130_fd_sc_hd__tapvpwrvgnd_1
X_4863_ _4970_/A0 hold317/X _4863_/S VGND VGND VPWR VPWR _5897_/D sky130_fd_sc_hd__mux2_1
XTAP_TAPCELL_ROW_15_371 VGND VPWR sky130_fd_sc_hd__tapvpwrvgnd_1
XFILLER_32_162 VGND VGND VPWR VPWR sky130_fd_sc_hd__decap_6
X_4794_ _5494_/Q hold143/X _4807_/S VGND VGND VPWR VPWR _5831_/D sky130_fd_sc_hd__mux2_1
XFILLER_60_493 VGND VGND VPWR VPWR sky130_fd_sc_hd__fill_1
X_3814_ _5572_/Q _3826_/S _3813_/X VGND VGND VPWR VPWR _5572_/D sky130_fd_sc_hd__o21ba_1
XFILLER_32_195 VGND VGND VPWR VPWR sky130_fd_sc_hd__fill_1
XANTENNA__4548__B2 _5737_/Q VGND VGND VPWR VPWR sky130_fd_sc_hd__diode_2
XANTENNA__3239__B _3240_/B VGND VGND VPWR VPWR sky130_fd_sc_hd__diode_2
X_3745_ _5754_/Q _5848_/Q _4870_/A1 VGND VGND VPWR VPWR _3745_/X sky130_fd_sc_hd__a21o_1
XANTENNA_fanout117_A _5096_/S VGND VGND VPWR VPWR sky130_fd_sc_hd__diode_2
X_3676_ _3709_/B _3676_/B _3709_/C _3676_/D VGND VGND VPWR VPWR _3676_/X sky130_fd_sc_hd__or4_1
X_5415_ _5415_/A _5415_/B VGND VGND VPWR VPWR _5416_/B sky130_fd_sc_hd__or2_1
X_5346_ _5344_/Y _5345_/X _5342_/X VGND VGND VPWR VPWR _6160_/D sky130_fd_sc_hd__a21o_1
XANTENNA__4785__S _4805_/S VGND VGND VPWR VPWR sky130_fd_sc_hd__diode_2
X_5277_ hold449/X _5249_/X _5327_/C _5276_/X VGND VGND VPWR VPWR _6149_/D sky130_fd_sc_hd__a22o_1
X_4228_ hold158/X _4227_/X _4246_/S VGND VGND VPWR VPWR _5707_/D sky130_fd_sc_hd__mux2_1
X_4159_ _5458_/B _4158_/Y _5459_/B VGND VGND VPWR VPWR _5700_/D sky130_fd_sc_hd__o21ba_1
XFILLER_46_26 VGND VGND VPWR VPWR sky130_fd_sc_hd__fill_2
XFILLER_70_213 VGND VGND VPWR VPWR sky130_fd_sc_hd__fill_1
XFILLER_24_641 VGND VGND VPWR VPWR sky130_fd_sc_hd__decap_3
Xclkbuf_leaf_35_clk clkload1/A VGND VGND VPWR VPWR _6163_/CLK sky130_fd_sc_hd__clkbuf_8
XFILLER_11_302 VPWR VGND VPWR VGND sky130_ef_sc_hd__decap_12
XFILLER_11_84 VGND VGND VPWR VPWR sky130_fd_sc_hd__decap_8
XANTENNA__4695__S _4735_/S VGND VGND VPWR VPWR sky130_fd_sc_hd__diode_2
XFILLER_19_413 VGND VGND VPWR VPWR sky130_fd_sc_hd__fill_1
XANTENNA__5019__A2 _5025_/A2 VGND VGND VPWR VPWR sky130_fd_sc_hd__diode_2
XFILLER_19_457 VGND VGND VPWR VPWR sky130_fd_sc_hd__fill_2
XFILLER_15_630 VGND VGND VPWR VPWR sky130_fd_sc_hd__decap_6
Xclkbuf_leaf_26_clk clkload2/A VGND VGND VPWR VPWR _6093_/CLK sky130_fd_sc_hd__clkbuf_8
XTAP_TAPCELL_ROW_60_926 VGND VPWR sky130_fd_sc_hd__tapvpwrvgnd_1
XANTENNA__2884__S0 _6114_/Q VGND VGND VPWR VPWR sky130_fd_sc_hd__diode_2
XFILLER_30_600 VGND VGND VPWR VPWR sky130_fd_sc_hd__decap_6
XFILLER_14_195 VGND VGND VPWR VPWR sky130_fd_sc_hd__fill_1
XANTENNA__3202__A1 _5473_/Q VGND VGND VPWR VPWR sky130_fd_sc_hd__diode_2
XTAP_TAPCELL_ROW_12_330 VGND VPWR sky130_fd_sc_hd__tapvpwrvgnd_1
XFILLER_30_699 VGND VGND VPWR VPWR sky130_fd_sc_hd__fill_1
X_3530_ _3530_/A _3530_/B VGND VGND VPWR VPWR _3530_/Y sky130_fd_sc_hd__xnor2_1
XTAP_TAPCELL_ROW_40_683 VGND VPWR sky130_fd_sc_hd__tapvpwrvgnd_1
XFILLER_6_383 VGND VGND VPWR VPWR sky130_fd_sc_hd__fill_2
X_3461_ hold108/X _2955_/Y _5353_/A VGND VGND VPWR VPWR _5565_/D sky130_fd_sc_hd__a21o_1
X_5200_ _5369_/A _5377_/A _5200_/C _6167_/Q VGND VGND VPWR VPWR _5203_/C sky130_fd_sc_hd__and4_1
X_3392_ _5989_/Q _6033_/Q _3394_/S VGND VGND VPWR VPWR _3392_/X sky130_fd_sc_hd__mux2_1
XFILLER_42_3 VPWR VGND VPWR VGND sky130_ef_sc_hd__decap_12
XANTENNA__4702__A1 _4750_/A1 VGND VGND VPWR VPWR sky130_fd_sc_hd__diode_2
X_5131_ hold341/X _4444_/B _5137_/S VGND VGND VPWR VPWR _6054_/D sky130_fd_sc_hd__mux2_1
XFILLER_69_368 VGND VGND VPWR VPWR sky130_fd_sc_hd__decap_6
X_5062_ hold413/X _5427_/A _5066_/S VGND VGND VPWR VPWR _5986_/D sky130_fd_sc_hd__mux2_1
X_4013_ _4014_/A _5649_/Q _5650_/Q VGND VGND VPWR VPWR _4015_/B sky130_fd_sc_hd__a21oi_1
XFILLER_37_254 VPWR VGND VPWR VGND sky130_ef_sc_hd__decap_12
XFILLER_80_522 VGND VGND VPWR VPWR sky130_fd_sc_hd__fill_1
XTAP_TAPCELL_ROW_48_783 VGND VPWR sky130_fd_sc_hd__tapvpwrvgnd_1
XFILLER_16_29 VGND VGND VPWR VPWR sky130_fd_sc_hd__decap_6
XANTENNA__3949__S _5353_/A VGND VGND VPWR VPWR sky130_fd_sc_hd__diode_2
XFILLER_25_449 VPWR VGND VPWR VGND sky130_ef_sc_hd__decap_12
Xclkbuf_leaf_17_clk clkbuf_leaf_9_clk/A VGND VGND VPWR VPWR _5963_/CLK sky130_fd_sc_hd__clkbuf_8
X_5964_ _5966_/CLK _5964_/D fanout305/X VGND VGND VPWR VPWR _5964_/Q sky130_fd_sc_hd__dfrtp_1
X_5895_ _6094_/CLK _5895_/D fanout345/X VGND VGND VPWR VPWR _5895_/Q sky130_fd_sc_hd__dfrtp_1
X_4915_ hold398/X _4948_/A2 _4914_/X VGND VGND VPWR VPWR _5914_/D sky130_fd_sc_hd__a21o_1
X_4846_ _5492_/Q hold258/X _4862_/S VGND VGND VPWR VPWR _5880_/D sky130_fd_sc_hd__mux2_1
XANTENNA_fanout234_A _3647_/A VGND VGND VPWR VPWR sky130_fd_sc_hd__diode_2
XANTENNA__5194__B2 _5739_/Q VGND VGND VPWR VPWR sky130_fd_sc_hd__diode_2
X_4777_ hold228/X _3905_/B _3765_/Y _2720_/Y VGND VGND VPWR VPWR _5815_/D sky130_fd_sc_hd__o22a_1
X_3728_ _4774_/S _4865_/B VGND VGND VPWR VPWR _3728_/X sky130_fd_sc_hd__or2_1
XFILLER_4_309 VPWR VGND VPWR VGND sky130_ef_sc_hd__decap_12
X_3659_ _3659_/A _3659_/B _3659_/C _3659_/D VGND VGND VPWR VPWR _3660_/D sky130_fd_sc_hd__or4_1
XFILLER_0_515 VGND VGND VPWR VPWR sky130_fd_sc_hd__fill_1
X_5329_ _6158_/Q _5337_/B VGND VGND VPWR VPWR _5329_/X sky130_fd_sc_hd__and2_1
XANTENNA__3901__C1 _3905_/B VGND VGND VPWR VPWR sky130_fd_sc_hd__diode_2
XFILLER_16_405 VGND VGND VPWR VPWR sky130_fd_sc_hd__decap_8
XFILLER_73_57 VGND VGND VPWR VPWR sky130_fd_sc_hd__decap_3
XANTENNA__4544__A _4544_/A VGND VGND VPWR VPWR sky130_fd_sc_hd__diode_2
XFILLER_43_279 VGND VGND VPWR VPWR sky130_fd_sc_hd__fill_1
XTAP_TAPCELL_ROW_26_499 VGND VPWR sky130_fd_sc_hd__tapvpwrvgnd_1
XFILLER_11_143 VGND VGND VPWR VPWR sky130_fd_sc_hd__fill_1
XANTENNA__5185__A1 _4517_/A VGND VGND VPWR VPWR sky130_fd_sc_hd__diode_2
XANTENNA__3196__A0 _2824_/C VGND VGND VPWR VPWR sky130_fd_sc_hd__diode_2
XFILLER_11_198 VGND VGND VPWR VPWR sky130_fd_sc_hd__fill_1
XANTENNA__5375__A _5377_/A VGND VGND VPWR VPWR sky130_fd_sc_hd__diode_2
XFILLER_22_72 VGND VGND VPWR VPWR sky130_fd_sc_hd__decap_4
XFILLER_3_353 VGND VGND VPWR VPWR sky130_fd_sc_hd__decap_4
XANTENNA__3499__B2 _6143_/D VGND VGND VPWR VPWR sky130_fd_sc_hd__diode_2
XANTENNA__3623__A _3623_/A VGND VGND VPWR VPWR sky130_fd_sc_hd__diode_2
XFILLER_66_316 VGND VGND VPWR VPWR sky130_fd_sc_hd__fill_1
XANTENNA__4448__B1 _4444_/B VGND VGND VPWR VPWR sky130_fd_sc_hd__diode_2
XFILLER_14_7 VGND VGND VPWR VPWR sky130_fd_sc_hd__fill_1
XTAP_TAPCELL_ROW_66_1003 VGND VPWR sky130_fd_sc_hd__tapvpwrvgnd_1
XFILLER_62_544 VGND VGND VPWR VPWR sky130_fd_sc_hd__fill_1
XFILLER_34_235 VGND VGND VPWR VPWR sky130_fd_sc_hd__fill_2
XTAP_TAPCELL_ROW_45_742 VGND VPWR sky130_fd_sc_hd__tapvpwrvgnd_1
XANTENNA__4620__B1 _4684_/B1 VGND VGND VPWR VPWR sky130_fd_sc_hd__diode_2
XFILLER_22_419 VGND VGND VPWR VPWR sky130_fd_sc_hd__fill_1
X_2961_ _2959_/X _2960_/X _3953_/B VGND VGND VPWR VPWR _2961_/X sky130_fd_sc_hd__mux2_1
XFILLER_15_482 VGND VGND VPWR VPWR sky130_fd_sc_hd__fill_1
X_5680_ _5682_/CLK _5680_/D fanout321/X VGND VGND VPWR VPWR _5680_/Q sky130_fd_sc_hd__dfrtp_1
X_4700_ _5961_/Q _4166_/C _4243_/S _4699_/X VGND VGND VPWR VPWR _4700_/X sky130_fd_sc_hd__a211o_1
X_2892_ _5842_/Q _2917_/A2 _2918_/B1 _5838_/Q VGND VGND VPWR VPWR _2892_/X sky130_fd_sc_hd__a22o_1
X_4631_ _5919_/Q _5760_/Q _4679_/S VGND VGND VPWR VPWR _4631_/X sky130_fd_sc_hd__mux2_1
XANTENNA__5176__A1 _4404_/A VGND VGND VPWR VPWR sky130_fd_sc_hd__diode_2
X_4562_ _5487_/Q _5793_/Q _4610_/S VGND VGND VPWR VPWR _4562_/X sky130_fd_sc_hd__mux2_1
XANTENNA__3726__A2 _3905_/B VGND VGND VPWR VPWR sky130_fd_sc_hd__diode_2
XTAP_TAPCELL_ROW_77_1143 VGND VPWR sky130_fd_sc_hd__tapvpwrvgnd_1
X_4493_ _4478_/A _4481_/Y _4491_/Y _4496_/A VGND VGND VPWR VPWR _4493_/X sky130_fd_sc_hd__a31o_1
X_3513_ _6118_/D _3517_/B VGND VGND VPWR VPWR _3523_/B sky130_fd_sc_hd__nand2_1
X_3444_ _5582_/Q hold94/X _3451_/S VGND VGND VPWR VPWR _5557_/D sky130_fd_sc_hd__mux2_1
Xclkbuf_leaf_6_clk clkbuf_leaf_9_clk/A VGND VGND VPWR VPWR _6110_/CLK sky130_fd_sc_hd__clkbuf_8
X_3375_ hold155/X _3396_/A _4544_/A _3374_/X VGND VGND VPWR VPWR _5505_/D sky130_fd_sc_hd__a22o_1
X_6163_ _6163_/CLK _6163_/D fanout312/X VGND VGND VPWR VPWR _6163_/Q sky130_fd_sc_hd__dfrtp_2
X_6094_ _6094_/CLK _6094_/D fanout349/X VGND VGND VPWR VPWR _6094_/Q sky130_fd_sc_hd__dfrtp_1
X_5114_ _6037_/Q _4427_/A _5122_/S VGND VGND VPWR VPWR _6037_/D sky130_fd_sc_hd__mux2_1
XANTENNA_hold10_X hold10/X VGND VGND VPWR VPWR sky130_fd_sc_hd__diode_2
XANTENNA__5521__Q _5521_/Q VGND VGND VPWR VPWR sky130_fd_sc_hd__diode_2
X_5045_ _3651_/B hold362/X _5054_/S VGND VGND VPWR VPWR _5969_/D sky130_fd_sc_hd__mux2_1
XANTENNA__5100__A1 _5377_/A VGND VGND VPWR VPWR sky130_fd_sc_hd__diode_2
XFILLER_25_213 VGND VGND VPWR VPWR sky130_fd_sc_hd__decap_8
XANTENNA_fanout351_A fanout352/X VGND VGND VPWR VPWR sky130_fd_sc_hd__diode_2
XFILLER_80_363 VGND VGND VPWR VPWR sky130_fd_sc_hd__fill_1
XANTENNA__4611__B1 _4667_/B1 VGND VGND VPWR VPWR sky130_fd_sc_hd__diode_2
X_5947_ _5952_/CLK _5947_/D fanout330/X VGND VGND VPWR VPWR _5947_/Q sky130_fd_sc_hd__dfrtp_1
XFILLER_40_216 VGND VGND VPWR VPWR sky130_fd_sc_hd__fill_1
XFILLER_43_49 VGND VGND VPWR VPWR sky130_fd_sc_hd__decap_6
XANTENNA__5167__A1 _5727_/Q VGND VGND VPWR VPWR sky130_fd_sc_hd__diode_2
X_5878_ _6091_/CLK _5878_/D fanout348/X VGND VGND VPWR VPWR _5878_/Q sky130_fd_sc_hd__dfrtp_1
XANTENNA_fanout237_X _3639_/A VGND VGND VPWR VPWR sky130_fd_sc_hd__diode_2
XTAP_TAPCELL_ROW_23_469 VGND VPWR sky130_fd_sc_hd__tapvpwrvgnd_1
X_4829_ _4408_/A _4829_/B _4829_/C VGND VGND VPWR VPWR _5138_/S sky130_fd_sc_hd__and3b_1
XANTENNA__3708__A _4873_/A VGND VGND VPWR VPWR sky130_fd_sc_hd__diode_2
XANTENNA__4303__S _5458_/C VGND VGND VPWR VPWR sky130_fd_sc_hd__diode_2
XANTENNA_fanout97_A _5170_/S VGND VGND VPWR VPWR sky130_fd_sc_hd__diode_2
XFILLER_68_46 VGND VGND VPWR VPWR sky130_fd_sc_hd__fill_1
XFILLER_0_389 VGND VGND VPWR VPWR sky130_fd_sc_hd__decap_3
XFILLER_76_658 VGND VGND VPWR VPWR sky130_fd_sc_hd__fill_1
XFILLER_75_113 VGND VGND VPWR VPWR sky130_fd_sc_hd__decap_3
XANTENNA__4973__S _4973_/S VGND VGND VPWR VPWR sky130_fd_sc_hd__diode_2
XANTENNA__4850__A0 _5468_/Q VGND VGND VPWR VPWR sky130_fd_sc_hd__diode_2
XANTENNA_fanout52_X _4686_/A1 VGND VGND VPWR VPWR sky130_fd_sc_hd__diode_2
XFILLER_44_511 VGND VGND VPWR VPWR sky130_fd_sc_hd__decap_8
XANTENNA__4602__A0 _5492_/Q VGND VGND VPWR VPWR sky130_fd_sc_hd__diode_2
XANTENNA__3405__A1 _5522_/Q VGND VGND VPWR VPWR sky130_fd_sc_hd__diode_2
XFILLER_16_268 VPWR VGND VPWR VGND sky130_ef_sc_hd__decap_12
XTAP_TAPCELL_ROW_42_701 VGND VPWR sky130_fd_sc_hd__tapvpwrvgnd_1
XANTENNA__5158__A1 _5468_/Q VGND VGND VPWR VPWR sky130_fd_sc_hd__diode_2
XANTENNA__3169__A0 _5522_/Q VGND VGND VPWR VPWR sky130_fd_sc_hd__diode_2
XFILLER_33_93 VGND VGND VPWR VPWR sky130_fd_sc_hd__fill_1
XFILLER_4_673 VPWR VGND VPWR VGND sky130_ef_sc_hd__decap_12
Xtt_um_bfcpu_362 VGND VGND VPWR VPWR tt_um_bfcpu_362/HI uio_out[7] sky130_fd_sc_hd__conb_1
XANTENNA__2895__C _2895_/C VGND VGND VPWR VPWR sky130_fd_sc_hd__diode_2
XFILLER_79_474 VGND VGND VPWR VPWR sky130_fd_sc_hd__fill_1
XTAP_TAPCELL_ROW_72_1084 VGND VPWR sky130_fd_sc_hd__tapvpwrvgnd_1
X_3160_ _5521_/Q _5491_/Q _5471_/Q _4964_/A0 _3150_/B _3150_/C VGND VGND VPWR VPWR
+ _3160_/X sky130_fd_sc_hd__mux4_1
Xhold1 hold1/A VGND VGND VPWR VPWR hold1/X sky130_fd_sc_hd__dlygate4sd3_1
X_3091_ _5677_/Q _5678_/Q _5679_/Q VGND VGND VPWR VPWR _3093_/B sky130_fd_sc_hd__a21oi_1
XANTENNA__4841__A0 _5487_/Q VGND VGND VPWR VPWR sky130_fd_sc_hd__diode_2
XFILLER_47_393 VGND VGND VPWR VPWR sky130_fd_sc_hd__fill_1
XPHY_EDGE_ROW_8_Right_8 VGND VGND VPWR VPWR sky130_fd_sc_hd__decap_3
X_5801_ clkload3/A _5801_/D fanout275/X VGND VGND VPWR VPWR _5801_/Q sky130_fd_sc_hd__dfrtp_1
X_5732_ _5732_/CLK _5732_/D fanout305/X VGND VGND VPWR VPWR _5732_/Q sky130_fd_sc_hd__dfrtp_1
X_3993_ _5624_/Q _5623_/Q _3987_/Y _5625_/Q VGND VGND VPWR VPWR _3996_/B sky130_fd_sc_hd__a31o_1
X_2944_ _6131_/D VGND VGND VPWR VPWR _3265_/B sky130_fd_sc_hd__inv_2
XANTENNA__5149__A1 _5487_/Q VGND VGND VPWR VPWR sky130_fd_sc_hd__diode_2
X_2875_ _2872_/X _2873_/X _2874_/X _2784_/X VGND VGND VPWR VPWR _2875_/X sky130_fd_sc_hd__o31a_1
XTAP_TAPCELL_ROW_20_428 VGND VPWR sky130_fd_sc_hd__tapvpwrvgnd_1
X_5663_ _5696_/CLK _5663_/D VGND VGND VPWR VPWR hold52/A sky130_fd_sc_hd__dfxtp_1
X_4614_ _4686_/A1 _4613_/X _4612_/X _4678_/C1 VGND VGND VPWR VPWR _4614_/X sky130_fd_sc_hd__o211a_1
X_5594_ _5697_/CLK _5594_/D fanout319/X VGND VGND VPWR VPWR _5594_/Q sky130_fd_sc_hd__dfrtp_1
Xhold401 _5943_/Q VGND VGND VPWR VPWR hold401/X sky130_fd_sc_hd__dlygate4sd3_1
X_4545_ _3887_/A _3396_/X _4823_/A2 VGND VGND VPWR VPWR _5754_/D sky130_fd_sc_hd__a21o_1
Xhold423 _5955_/Q VGND VGND VPWR VPWR hold423/X sky130_fd_sc_hd__dlygate4sd3_1
Xhold445 _6158_/Q VGND VGND VPWR VPWR hold445/X sky130_fd_sc_hd__dlygate4sd3_1
Xhold412 _5616_/Q VGND VGND VPWR VPWR hold412/X sky130_fd_sc_hd__dlygate4sd3_1
Xhold434 _6031_/Q VGND VGND VPWR VPWR hold434/X sky130_fd_sc_hd__dlygate4sd3_1
Xhold456 _5917_/Q VGND VGND VPWR VPWR hold456/X sky130_fd_sc_hd__dlygate4sd3_1
Xhold467 _5929_/Q VGND VGND VPWR VPWR hold467/X sky130_fd_sc_hd__dlygate4sd3_1
X_4476_ _4487_/B _4530_/B VGND VGND VPWR VPWR _4478_/A sky130_fd_sc_hd__nand2_1
Xhold478 _5616_/Q VGND VGND VPWR VPWR hold478/X sky130_fd_sc_hd__dlygate4sd3_1
XANTENNA__4359__A _5737_/Q VGND VGND VPWR VPWR sky130_fd_sc_hd__diode_2
X_3427_ hold45/X _5582_/Q _3434_/S VGND VGND VPWR VPWR _5541_/D sky130_fd_sc_hd__mux2_1
XPHY_EDGE_ROW_39_Right_39 VGND VGND VPWR VPWR sky130_fd_sc_hd__decap_3
X_6146_ _6161_/CLK _6146_/D fanout310/X VGND VGND VPWR VPWR _6146_/Q sky130_fd_sc_hd__dfrtp_1
X_3358_ _3358_/A _3358_/B _3358_/C VGND VGND VPWR VPWR _3359_/C sky130_fd_sc_hd__or3_1
XANTENNA__4793__S _4809_/S VGND VGND VPWR VPWR sky130_fd_sc_hd__diode_2
X_6077_ _6085_/CLK _6077_/D fanout344/X VGND VGND VPWR VPWR _6077_/Q sky130_fd_sc_hd__dfrtp_1
XANTENNA_fanout187_X _5447_/A VGND VGND VPWR VPWR sky130_fd_sc_hd__diode_2
X_3289_ _5201_/B _3270_/B _3333_/A VGND VGND VPWR VPWR _3289_/X sky130_fd_sc_hd__a21o_1
X_5028_ _4693_/X _4979_/A _4979_/B _4952_/X VGND VGND VPWR VPWR _5028_/X sky130_fd_sc_hd__a22o_1
XTAP_TAPCELL_ROW_28_528 VGND VPWR sky130_fd_sc_hd__tapvpwrvgnd_1
XANTENNA__3202__S _3203_/S VGND VGND VPWR VPWR sky130_fd_sc_hd__diode_2
XFILLER_54_15 VGND VGND VPWR VPWR sky130_fd_sc_hd__decap_4
XTAP_TAPCELL_ROW_0_164 VGND VPWR sky130_fd_sc_hd__tapvpwrvgnd_1
XTAP_TAPCELL_ROW_0_175 VGND VPWR sky130_fd_sc_hd__tapvpwrvgnd_1
XTAP_TAPCELL_ROW_0_186 VGND VPWR sky130_fd_sc_hd__tapvpwrvgnd_1
XPHY_EDGE_ROW_48_Right_48 VGND VGND VPWR VPWR sky130_fd_sc_hd__decap_3
XFILLER_13_227 VGND VGND VPWR VPWR sky130_fd_sc_hd__decap_3
XFILLER_79_45 VGND VGND VPWR VPWR sky130_fd_sc_hd__fill_1
XPHY_EDGE_ROW_57_Right_57 VGND VGND VPWR VPWR sky130_fd_sc_hd__decap_3
XFILLER_1_632 VPWR VGND VPWR VGND sky130_ef_sc_hd__decap_12
XTAP_TAPCELL_ROW_8_286 VGND VPWR sky130_fd_sc_hd__tapvpwrvgnd_1
XTAP_TAPCELL_ROW_8_275 VGND VPWR sky130_fd_sc_hd__tapvpwrvgnd_1
XANTENNA__3460__X _5353_/A VGND VGND VPWR VPWR sky130_fd_sc_hd__diode_2
XFILLER_28_93 VGND VGND VPWR VPWR sky130_fd_sc_hd__fill_1
XFILLER_63_149 VGND VGND VPWR VPWR sky130_fd_sc_hd__decap_3
XFILLER_29_393 VGND VGND VPWR VPWR sky130_fd_sc_hd__decap_4
XPHY_EDGE_ROW_66_Right_66 VGND VGND VPWR VPWR sky130_fd_sc_hd__decap_3
XTAP_TAPCELL_ROW_55_870 VGND VPWR sky130_fd_sc_hd__tapvpwrvgnd_1
XFILLER_8_253 VPWR VGND VPWR VGND sky130_ef_sc_hd__decap_12
XFILLER_8_231 VGND VGND VPWR VPWR sky130_fd_sc_hd__decap_8
XANTENNA__5000__B1 _5024_/B1 VGND VGND VPWR VPWR sky130_fd_sc_hd__diode_2
XPHY_EDGE_ROW_75_Right_75 VGND VGND VPWR VPWR sky130_fd_sc_hd__decap_3
XTAP_TAPCELL_ROW_74_1102 VGND VPWR sky130_fd_sc_hd__tapvpwrvgnd_1
XANTENNA__6059__RESET_B fanout283/X VGND VGND VPWR VPWR sky130_fd_sc_hd__diode_2
X_4330_ _4338_/C VGND VGND VPWR VPWR _4330_/Y sky130_fd_sc_hd__inv_2
X_4261_ _4250_/Y _4259_/X _4260_/X VGND VGND VPWR VPWR _4262_/B sky130_fd_sc_hd__a21oi_1
X_6000_ _6088_/CLK _6000_/D fanout338/X VGND VGND VPWR VPWR _6000_/Q sky130_fd_sc_hd__dfrtp_1
X_3212_ hold12/X _5635_/Q _3219_/S VGND VGND VPWR VPWR hold13/A sky130_fd_sc_hd__mux2_1
X_4192_ hold180/X _4191_/A _4246_/S VGND VGND VPWR VPWR _5703_/D sky130_fd_sc_hd__mux2_1
XANTENNA__6167__Q _6167_/Q VGND VGND VPWR VPWR sky130_fd_sc_hd__diode_2
X_3143_ _5947_/Q _3153_/B VGND VGND VPWR VPWR _3143_/X sky130_fd_sc_hd__or2_1
X_3074_ _3067_/Y _3068_/X _3070_/X _3071_/Y _3072_/X VGND VGND VPWR VPWR _3075_/D
+ sky130_fd_sc_hd__a221o_1
XFILLER_54_138 VGND VGND VPWR VPWR sky130_fd_sc_hd__fill_2
XFILLER_23_503 VGND VGND VPWR VPWR sky130_fd_sc_hd__fill_1
XFILLER_24_29 VGND VGND VPWR VPWR sky130_fd_sc_hd__fill_1
XFILLER_23_558 VGND VGND VPWR VPWR sky130_fd_sc_hd__fill_2
X_3976_ _3976_/A _3976_/B VGND VGND VPWR VPWR _3977_/C sky130_fd_sc_hd__or2_1
X_2927_ _6010_/Q _2895_/C _2927_/B1 _6014_/Q VGND VGND VPWR VPWR _2927_/X sky130_fd_sc_hd__a22o_1
X_5715_ _5723_/CLK _5715_/D fanout293/X VGND VGND VPWR VPWR _5715_/Q sky130_fd_sc_hd__dfrtp_4
XANTENNA__4361__B _5736_/Q VGND VGND VPWR VPWR sky130_fd_sc_hd__diode_2
XTAP_TAPCELL_ROW_33_597 VGND VPWR sky130_fd_sc_hd__tapvpwrvgnd_1
X_5646_ _5690_/CLK _5646_/D fanout317/X VGND VGND VPWR VPWR _5646_/Q sky130_fd_sc_hd__dfstp_1
XANTENNA_fanout314_A fanout324/X VGND VGND VPWR VPWR sky130_fd_sc_hd__diode_2
X_2858_ _5880_/Q _2910_/B _2921_/A2 _5892_/Q VGND VGND VPWR VPWR _2858_/X sky130_fd_sc_hd__a22o_1
Xhold220 _6078_/Q VGND VGND VPWR VPWR hold220/X sky130_fd_sc_hd__dlygate4sd3_1
X_2789_ _2864_/A _2920_/B _2925_/B VGND VGND VPWR VPWR _2789_/X sky130_fd_sc_hd__and3_1
XANTENNA__4788__S _4810_/S VGND VGND VPWR VPWR sky130_fd_sc_hd__diode_2
X_5577_ _5811_/CLK _5577_/D fanout288/X VGND VGND VPWR VPWR _5577_/Q sky130_fd_sc_hd__dfrtp_2
XANTENNA__4750__C1 _4750_/C1 VGND VGND VPWR VPWR sky130_fd_sc_hd__diode_2
Xhold231 _6068_/Q VGND VGND VPWR VPWR hold231/X sky130_fd_sc_hd__dlygate4sd3_1
Xhold253 _5771_/Q VGND VGND VPWR VPWR hold253/X sky130_fd_sc_hd__dlygate4sd3_1
X_4528_ _4522_/C _4357_/B _4462_/A _4527_/X VGND VGND VPWR VPWR _5749_/D sky130_fd_sc_hd__a22o_1
Xhold242 _6118_/Q VGND VGND VPWR VPWR hold242/X sky130_fd_sc_hd__dlygate4sd3_1
Xhold275 _5834_/Q VGND VGND VPWR VPWR hold275/X sky130_fd_sc_hd__dlygate4sd3_1
Xhold264 _5886_/Q VGND VGND VPWR VPWR hold264/X sky130_fd_sc_hd__dlygate4sd3_1
Xhold286 _6080_/Q VGND VGND VPWR VPWR hold286/X sky130_fd_sc_hd__dlygate4sd3_1
X_4459_ _4467_/A _4460_/B VGND VGND VPWR VPWR _4487_/C sky130_fd_sc_hd__and2_1
Xhold297 _6004_/Q VGND VGND VPWR VPWR hold297/X sky130_fd_sc_hd__dlygate4sd3_1
XTAP_TAPCELL_ROW_5_245 VGND VPWR sky130_fd_sc_hd__tapvpwrvgnd_1
XFILLER_58_455 VGND VGND VPWR VPWR sky130_fd_sc_hd__fill_1
XFILLER_58_444 VGND VGND VPWR VPWR sky130_fd_sc_hd__fill_1
X_6129_ _6131_/CLK _6129_/D fanout328/X VGND VGND VPWR VPWR _6129_/Q sky130_fd_sc_hd__dfstp_1
XANTENNA__4805__A0 _5094_/A1 VGND VGND VPWR VPWR sky130_fd_sc_hd__diode_2
XFILLER_46_628 VGND VGND VPWR VPWR sky130_fd_sc_hd__fill_1
XFILLER_73_447 VGND VGND VPWR VPWR sky130_fd_sc_hd__fill_1
XFILLER_26_363 VGND VGND VPWR VPWR sky130_fd_sc_hd__fill_1
XANTENNA__4698__S _4746_/S VGND VGND VPWR VPWR sky130_fd_sc_hd__diode_2
XFILLER_5_223 VGND VGND VPWR VPWR sky130_fd_sc_hd__fill_1
XANTENNA__6152__RESET_B fanout310/X VGND VGND VPWR VPWR sky130_fd_sc_hd__diode_2
XANTENNA__2898__A2 _2910_/B VGND VGND VPWR VPWR sky130_fd_sc_hd__diode_2
XFILLER_5_267 VPWR VGND VPWR VGND sky130_ef_sc_hd__decap_12
XFILLER_30_83 VGND VGND VPWR VPWR sky130_fd_sc_hd__fill_1
XANTENNA__5049__A0 _3623_/A VGND VGND VPWR VPWR sky130_fd_sc_hd__diode_2
XANTENNA__3631__A _3651_/B VGND VGND VPWR VPWR sky130_fd_sc_hd__diode_2
XFILLER_51_108 VGND VGND VPWR VPWR sky130_fd_sc_hd__decap_4
XFILLER_45_650 VGND VGND VPWR VPWR sky130_fd_sc_hd__fill_1
XFILLER_32_333 VGND VGND VPWR VPWR sky130_fd_sc_hd__decap_8
X_3830_ _5808_/Q _5509_/Q _3904_/S VGND VGND VPWR VPWR _3830_/X sky130_fd_sc_hd__mux2_1
X_3761_ _4813_/A1 _3725_/C _3760_/X _3905_/B VGND VGND VPWR VPWR _3761_/X sky130_fd_sc_hd__a211o_1
XTAP_TAPCELL_ROW_80_1194 VGND VPWR sky130_fd_sc_hd__tapvpwrvgnd_1
XTAP_TAPCELL_ROW_80_1183 VGND VPWR sky130_fd_sc_hd__tapvpwrvgnd_1
X_5500_ _6149_/CLK _5500_/D VGND VGND VPWR VPWR hold53/A sky130_fd_sc_hd__dfxtp_1
XFILLER_72_3 VPWR VGND VPWR VGND sky130_ef_sc_hd__decap_12
X_3692_ _4491_/A _6058_/Q _3713_/D _3691_/X VGND VGND VPWR VPWR _3693_/C sky130_fd_sc_hd__a211o_1
XTAP_TAPCELL_ROW_30_556 VGND VPWR sky130_fd_sc_hd__tapvpwrvgnd_1
X_5431_ _5429_/X _5430_/X _5428_/X VGND VGND VPWR VPWR _5431_/Y sky130_fd_sc_hd__o21ai_1
X_5362_ _6163_/Q _5362_/B _5362_/C VGND VGND VPWR VPWR _5363_/B sky130_fd_sc_hd__or3_1
X_4313_ _5718_/Q _2837_/B _5187_/B VGND VGND VPWR VPWR _5718_/D sky130_fd_sc_hd__a21o_1
X_5293_ _5301_/A _5293_/B VGND VGND VPWR VPWR _5296_/A sky130_fd_sc_hd__and2_1
X_4244_ _4175_/A _4876_/A _3748_/Y _4243_/X VGND VGND VPWR VPWR _4244_/X sky130_fd_sc_hd__o31a_1
XTAP_TAPCELL_ROW_2_204 VGND VPWR sky130_fd_sc_hd__tapvpwrvgnd_1
X_4175_ _4175_/A _4977_/A _4175_/C _4175_/D VGND VGND VPWR VPWR _4175_/X sky130_fd_sc_hd__or4_1
X_3126_ _3126_/A _3126_/B VGND VGND VPWR VPWR _6138_/D sky130_fd_sc_hd__nand2_1
XFILLER_55_447 VGND VGND VPWR VPWR sky130_fd_sc_hd__fill_1
XANTENNA__4356__B _4475_/B VGND VGND VPWR VPWR sky130_fd_sc_hd__diode_2
XANTENNA__4263__A1 _5458_/C VGND VGND VPWR VPWR sky130_fd_sc_hd__diode_2
XTAP_TAPCELL_ROW_38_656 VGND VPWR sky130_fd_sc_hd__tapvpwrvgnd_1
X_3057_ _5619_/Q _3057_/B _5621_/Q _5618_/Q VGND VGND VPWR VPWR _3057_/X sky130_fd_sc_hd__or4bb_1
XANTENNA__2813__A2 _2786_/X VGND VGND VPWR VPWR sky130_fd_sc_hd__diode_2
XANTENNA__5187__B _5187_/B VGND VGND VPWR VPWR sky130_fd_sc_hd__diode_2
XFILLER_51_49 VGND VGND VPWR VPWR sky130_fd_sc_hd__decap_6
X_3959_ _3960_/B _3959_/B VGND VGND VPWR VPWR _5612_/D sky130_fd_sc_hd__nor2_1
X_5629_ _5645_/CLK hold8/X VGND VGND VPWR VPWR hold4/A sky130_fd_sc_hd__dfxtp_1
XANTENNA__3829__A1 _5412_/A VGND VGND VPWR VPWR sky130_fd_sc_hd__diode_2
XANTENNA__5142__S _5166_/S VGND VGND VPWR VPWR sky130_fd_sc_hd__diode_2
XFILLER_76_79 VGND VGND VPWR VPWR sky130_fd_sc_hd__decap_4
XFILLER_19_617 VGND VGND VPWR VPWR sky130_fd_sc_hd__decap_8
XFILLER_73_266 VGND VGND VPWR VPWR sky130_fd_sc_hd__fill_1
XFILLER_27_683 VGND VGND VPWR VPWR sky130_fd_sc_hd__fill_1
XFILLER_41_152 VPWR VGND VPWR VGND sky130_ef_sc_hd__decap_12
XANTENNA__3765__B1 _4175_/D VGND VGND VPWR VPWR sky130_fd_sc_hd__diode_2
XANTENNA__3626__A _3626_/A VGND VGND VPWR VPWR sky130_fd_sc_hd__diode_2
XFILLER_6_598 VGND VGND VPWR VPWR sky130_fd_sc_hd__decap_4
XFILLER_44_7 VGND VGND VPWR VPWR sky130_fd_sc_hd__fill_1
XFILLER_1_281 VPWR VGND VPWR VGND sky130_ef_sc_hd__decap_12
XFILLER_2_65 VPWR VGND VPWR VGND sky130_ef_sc_hd__decap_12
XTAP_TAPCELL_ROW_69_1045 VGND VPWR sky130_fd_sc_hd__tapvpwrvgnd_1
XANTENNA__4245__A1 _4226_/S VGND VGND VPWR VPWR sky130_fd_sc_hd__diode_2
X_5980_ clkload5/A _5980_/D fanout281/X VGND VGND VPWR VPWR _5980_/Q sky130_fd_sc_hd__dfrtp_1
X_4931_ _5468_/Q _4634_/X _4973_/S VGND VGND VPWR VPWR _4931_/X sky130_fd_sc_hd__mux2_1
XFILLER_33_620 VGND VGND VPWR VPWR sky130_fd_sc_hd__fill_2
XTAP_TAPCELL_ROW_35_615 VGND VPWR sky130_fd_sc_hd__tapvpwrvgnd_1
XTAP_TAPCELL_ROW_63_968 VGND VPWR sky130_fd_sc_hd__tapvpwrvgnd_1
X_4862_ _4967_/A0 hold171/X _4862_/S VGND VGND VPWR VPWR _5896_/D sky130_fd_sc_hd__mux2_1
XFILLER_32_141 VGND VGND VPWR VPWR sky130_fd_sc_hd__fill_1
X_3813_ _3773_/A _3810_/X _3834_/C _3812_/Y _3826_/S VGND VGND VPWR VPWR _3813_/X
+ sky130_fd_sc_hd__o221a_1
X_4793_ _5493_/Q hold232/X _4809_/S VGND VGND VPWR VPWR _5830_/D sky130_fd_sc_hd__mux2_1
XTAP_TAPCELL_ROW_15_372 VGND VPWR sky130_fd_sc_hd__tapvpwrvgnd_1
X_3744_ _5567_/Q _3743_/X _3759_/S VGND VGND VPWR VPWR _5567_/D sky130_fd_sc_hd__mux2_1
X_3675_ _3709_/A _3711_/B _3709_/D _3674_/Y VGND VGND VPWR VPWR _3676_/D sky130_fd_sc_hd__or4b_1
X_5414_ _5430_/A _5414_/B VGND VGND VPWR VPWR _5416_/A sky130_fd_sc_hd__nor2_1
XANTENNA__5524__Q _5524_/Q VGND VGND VPWR VPWR sky130_fd_sc_hd__diode_2
X_5345_ _5338_/A _5339_/X _5343_/X _5327_/C VGND VGND VPWR VPWR _5345_/X sky130_fd_sc_hd__o31a_1
X_5276_ _5276_/A _5276_/B VGND VGND VPWR VPWR _5276_/X sky130_fd_sc_hd__xor2_1
XFILLER_75_509 VGND VGND VPWR VPWR sky130_fd_sc_hd__fill_1
X_4227_ _4227_/A _4227_/B VGND VGND VPWR VPWR _4227_/X sky130_fd_sc_hd__or2_1
X_4158_ _5700_/Q _4158_/B VGND VGND VPWR VPWR _4158_/Y sky130_fd_sc_hd__xnor2_1
XFILLER_55_233 VGND VGND VPWR VPWR sky130_fd_sc_hd__fill_1
XFILLER_55_277 VGND VGND VPWR VPWR sky130_fd_sc_hd__fill_1
X_3109_ _3955_/A _3109_/B VGND VGND VPWR VPWR _3109_/X sky130_fd_sc_hd__and2b_1
X_4089_ _5587_/Q hold56/X _4091_/S VGND VGND VPWR VPWR _5696_/D sky130_fd_sc_hd__mux2_1
XFILLER_43_428 VGND VGND VPWR VPWR sky130_fd_sc_hd__fill_1
XFILLER_62_15 VPWR VGND VPWR VGND sky130_ef_sc_hd__decap_12
XFILLER_11_358 VGND VGND VPWR VPWR sky130_fd_sc_hd__decap_3
XFILLER_2_3 VPWR VGND VPWR VGND sky130_ef_sc_hd__decap_12
XANTENNA_fanout82_X _4175_/D VGND VGND VPWR VPWR sky130_fd_sc_hd__diode_2
XFILLER_36_60 VGND VGND VPWR VPWR sky130_fd_sc_hd__decap_4
XFILLER_61_247 VGND VGND VPWR VPWR sky130_fd_sc_hd__decap_3
XFILLER_61_236 VGND VGND VPWR VPWR sky130_fd_sc_hd__fill_1
XTAP_TAPCELL_ROW_60_927 VGND VPWR sky130_fd_sc_hd__tapvpwrvgnd_1
XFILLER_42_483 VGND VGND VPWR VPWR sky130_fd_sc_hd__fill_1
XTAP_TAPCELL_ROW_12_331 VGND VPWR sky130_fd_sc_hd__tapvpwrvgnd_1
XTAP_TAPCELL_ROW_40_684 VGND VPWR sky130_fd_sc_hd__tapvpwrvgnd_1
XANTENNA__4950__A2 _4950_/A2 VGND VGND VPWR VPWR sky130_fd_sc_hd__diode_2
X_3460_ _6126_/Q _3932_/B VGND VGND VPWR VPWR _5353_/A sky130_fd_sc_hd__and2_4
X_3391_ hold164/X _3396_/A _4870_/A1 _3390_/X VGND VGND VPWR VPWR _5513_/D sky130_fd_sc_hd__a22o_1
X_5130_ hold352/X _4447_/A _5137_/S VGND VGND VPWR VPWR _6053_/D sky130_fd_sc_hd__mux2_1
XFILLER_35_3 VPWR VGND VPWR VGND sky130_ef_sc_hd__decap_12
X_5061_ _5985_/Q _6171_/Q _5066_/S VGND VGND VPWR VPWR _5985_/D sky130_fd_sc_hd__mux2_1
X_4012_ _4014_/A _5649_/Q _4011_/Y VGND VGND VPWR VPWR _5649_/D sky130_fd_sc_hd__o21a_1
XFILLER_37_222 VGND VGND VPWR VPWR sky130_fd_sc_hd__fill_2
XFILLER_37_266 VGND VGND VPWR VPWR sky130_fd_sc_hd__fill_2
X_5963_ _5963_/CLK _5963_/D fanout308/X VGND VGND VPWR VPWR _5963_/Q sky130_fd_sc_hd__dfrtp_1
XTAP_TAPCELL_ROW_48_784 VGND VPWR sky130_fd_sc_hd__tapvpwrvgnd_1
X_4914_ _4591_/X _4950_/A2 _4950_/B1 _4913_/X VGND VGND VPWR VPWR _4914_/X sky130_fd_sc_hd__a22o_1
X_5894_ _6091_/CLK _5894_/D fanout348/X VGND VGND VPWR VPWR _5894_/Q sky130_fd_sc_hd__dfrtp_1
X_4845_ _5491_/Q hold327/X _4863_/S VGND VGND VPWR VPWR _5879_/D sky130_fd_sc_hd__mux2_1
X_4776_ hold105/X _3902_/X _4776_/S VGND VGND VPWR VPWR _5814_/D sky130_fd_sc_hd__mux2_1
XANTENNA_clkbuf_leaf_12_clk_A clkbuf_leaf_9_clk/A VGND VGND VPWR VPWR sky130_fd_sc_hd__diode_2
X_3727_ _5900_/Q _4866_/S _5901_/Q _5719_/Q VGND VGND VPWR VPWR _4865_/B sky130_fd_sc_hd__o31a_1
XFILLER_20_177 VPWR VGND VPWR VGND sky130_ef_sc_hd__decap_12
XANTENNA_fanout227_A _5754_/Q VGND VGND VPWR VPWR sky130_fd_sc_hd__diode_2
X_3658_ _3694_/B _3658_/B _3720_/C _3697_/C VGND VGND VPWR VPWR _3659_/D sky130_fd_sc_hd__or4_1
XANTENNA__4796__S _4810_/S VGND VGND VPWR VPWR sky130_fd_sc_hd__diode_2
X_3589_ _6098_/Q _4399_/A VGND VGND VPWR VPWR _3711_/B sky130_fd_sc_hd__nor2_1
XANTENNA_clkbuf_leaf_27_clk_A clkload2/A VGND VGND VPWR VPWR sky130_fd_sc_hd__diode_2
X_5328_ hold458/X _5341_/B2 _5327_/X VGND VGND VPWR VPWR _6157_/D sky130_fd_sc_hd__a21o_1
X_5259_ _6146_/Q _5252_/X _5258_/Y fanout9/X VGND VGND VPWR VPWR _6146_/D sky130_fd_sc_hd__a22o_1
XFILLER_29_712 VGND VGND VPWR VPWR sky130_fd_sc_hd__fill_1
Xclkbuf_2_2__f_clk clkbuf_0_clk/X VGND VGND VPWR VPWR clkload1/A sky130_fd_sc_hd__clkbuf_16
XFILLER_73_69 VPWR VGND VPWR VGND sky130_ef_sc_hd__decap_12
XANTENNA_fanout42_A _4747_/B1 VGND VGND VPWR VPWR sky130_fd_sc_hd__diode_2
XFILLER_12_645 VPWR VGND VPWR VGND sky130_ef_sc_hd__decap_12
XANTENNA__3196__A1 _5467_/Q VGND VGND VPWR VPWR sky130_fd_sc_hd__diode_2
XFILLER_11_177 VGND VGND VPWR VPWR sky130_fd_sc_hd__fill_1
XANTENNA__5907__RESET_B fanout306/X VGND VGND VPWR VPWR sky130_fd_sc_hd__diode_2
XANTENNA__4932__A2 _4950_/A2 VGND VGND VPWR VPWR sky130_fd_sc_hd__diode_2
XANTENNA__4696__B2 _4226_/S VGND VGND VPWR VPWR sky130_fd_sc_hd__diode_2
XANTENNA__5391__A _6167_/Q VGND VGND VPWR VPWR sky130_fd_sc_hd__diode_2
XFILLER_59_391 VGND VGND VPWR VPWR sky130_fd_sc_hd__fill_1
Xfanout190 _6170_/Q VGND VGND VPWR VPWR _5412_/A sky130_fd_sc_hd__buf_2
XANTENNA__4999__A2 _5027_/A2 VGND VGND VPWR VPWR sky130_fd_sc_hd__diode_2
XTAP_TAPCELL_ROW_66_1004 VGND VPWR sky130_fd_sc_hd__tapvpwrvgnd_1
XFILLER_19_277 VGND VGND VPWR VPWR sky130_fd_sc_hd__fill_1
XFILLER_34_203 VGND VGND VPWR VPWR sky130_fd_sc_hd__decap_8
XTAP_TAPCELL_ROW_45_743 VGND VPWR sky130_fd_sc_hd__tapvpwrvgnd_1
X_2960_ hold41/A hold12/A hold73/A hold23/A _3954_/A _3955_/A VGND VGND VPWR VPWR
+ _2960_/X sky130_fd_sc_hd__mux4_1
XFILLER_34_269 VGND VGND VPWR VPWR sky130_fd_sc_hd__fill_1
X_2891_ _5830_/Q _2786_/X _2916_/B _5826_/Q VGND VGND VPWR VPWR _2891_/X sky130_fd_sc_hd__a22o_1
XFILLER_63_91 VGND VGND VPWR VPWR sky130_fd_sc_hd__fill_1
X_4630_ _4686_/A1 _4629_/X _4678_/C1 VGND VGND VPWR VPWR _4630_/X sky130_fd_sc_hd__o21a_1
XANTENNA__4923__A2 _4950_/A2 VGND VGND VPWR VPWR sky130_fd_sc_hd__diode_2
XANTENNA__3726__A3 _3725_/C VGND VGND VPWR VPWR sky130_fd_sc_hd__diode_2
X_4561_ _4561_/A _4561_/B VGND VGND VPWR VPWR _4561_/Y sky130_fd_sc_hd__nor2_1
XTAP_TAPCELL_ROW_77_1144 VGND VPWR sky130_fd_sc_hd__tapvpwrvgnd_1
X_4492_ _4478_/A _4481_/Y _4491_/Y VGND VGND VPWR VPWR _4492_/Y sky130_fd_sc_hd__a21oi_1
X_3512_ _3538_/A _3545_/B VGND VGND VPWR VPWR _3546_/B sky130_fd_sc_hd__nand2_2
X_3443_ _5465_/Q _4083_/A _3443_/C VGND VGND VPWR VPWR _3451_/S sky130_fd_sc_hd__or3_4
XANTENNA__4687__A1 _5767_/Q VGND VGND VPWR VPWR sky130_fd_sc_hd__diode_2
X_6162_ _6176_/CLK _6162_/D fanout312/X VGND VGND VPWR VPWR _6162_/Q sky130_fd_sc_hd__dfrtp_4
X_5113_ hold310/X _3651_/B _5122_/S VGND VGND VPWR VPWR _6036_/D sky130_fd_sc_hd__mux2_1
X_3374_ _5980_/Q _6024_/Q _3394_/S VGND VGND VPWR VPWR _3374_/X sky130_fd_sc_hd__mux2_1
X_6093_ _6093_/CLK _6093_/D fanout346/X VGND VGND VPWR VPWR _6093_/Q sky130_fd_sc_hd__dfrtp_1
X_5044_ _4404_/A _5968_/Q _5054_/S VGND VGND VPWR VPWR _5968_/D sky130_fd_sc_hd__mux2_1
XFILLER_72_309 VGND VGND VPWR VPWR sky130_fd_sc_hd__fill_1
XFILLER_65_383 VGND VGND VPWR VPWR sky130_fd_sc_hd__fill_1
XFILLER_25_225 VGND VGND VPWR VPWR sky130_fd_sc_hd__decap_6
X_5946_ _6142_/CLK _5946_/D fanout326/X VGND VGND VPWR VPWR _5946_/Q sky130_fd_sc_hd__dfrtp_1
XFILLER_80_397 VPWR VGND VPWR VGND sky130_ef_sc_hd__decap_12
X_5877_ _6085_/CLK _5877_/D fanout333/X VGND VGND VPWR VPWR _5877_/Q sky130_fd_sc_hd__dfrtp_1
XFILLER_40_239 VPWR VGND VPWR VGND sky130_ef_sc_hd__decap_12
XANTENNA_fanout132_X _4809_/S VGND VGND VPWR VPWR sky130_fd_sc_hd__diode_2
XANTENNA__4380__A _4829_/C VGND VGND VPWR VPWR sky130_fd_sc_hd__diode_2
X_4828_ _5864_/Q _2964_/B _3268_/B _4828_/B2 VGND VGND VPWR VPWR _5864_/D sky130_fd_sc_hd__a22o_1
XANTENNA__4914__A2 _4950_/A2 VGND VGND VPWR VPWR sky130_fd_sc_hd__diode_2
X_4759_ _5798_/Q _4761_/A2 _4561_/B _3541_/Y VGND VGND VPWR VPWR _5798_/D sky130_fd_sc_hd__a22o_1
XANTENNA__4678__A1 _4678_/A1 VGND VGND VPWR VPWR sky130_fd_sc_hd__diode_2
XFILLER_68_36 VGND VGND VPWR VPWR sky130_fd_sc_hd__fill_1
XFILLER_48_317 VGND VGND VPWR VPWR sky130_fd_sc_hd__fill_1
XANTENNA__6177__RESET_B fanout298/X VGND VGND VPWR VPWR sky130_fd_sc_hd__diode_2
XFILLER_56_361 VGND VGND VPWR VPWR sky130_fd_sc_hd__decap_3
XANTENNA__5150__S _5166_/S VGND VGND VPWR VPWR sky130_fd_sc_hd__diode_2
XFILLER_16_203 VGND VGND VPWR VPWR sky130_fd_sc_hd__fill_1
XANTENNA_fanout45_X _4684_/B1 VGND VGND VPWR VPWR sky130_fd_sc_hd__diode_2
XFILLER_71_364 VPWR VGND VPWR VGND sky130_ef_sc_hd__decap_12
XTAP_TAPCELL_ROW_42_702 VGND VPWR sky130_fd_sc_hd__tapvpwrvgnd_1
XFILLER_12_431 VPWR VGND VPWR VGND sky130_ef_sc_hd__decap_12
XFILLER_33_61 VGND VGND VPWR VPWR sky130_fd_sc_hd__fill_1
XANTENNA__3169__A1 _5492_/Q VGND VGND VPWR VPWR sky130_fd_sc_hd__diode_2
XANTENNA__4669__A1 _5765_/Q VGND VGND VPWR VPWR sky130_fd_sc_hd__diode_2
XFILLER_4_685 VPWR VGND VPWR VGND sky130_ef_sc_hd__decap_12
Xtt_um_bfcpu_363 VGND VGND VPWR VPWR tt_um_bfcpu_363/HI uo_out[1] sky130_fd_sc_hd__conb_1
XTAP_TAPCELL_ROW_72_1085 VGND VPWR sky130_fd_sc_hd__tapvpwrvgnd_1
XTAP_TAPCELL_ROW_72_1074 VGND VPWR sky130_fd_sc_hd__tapvpwrvgnd_1
XFILLER_67_615 VGND VGND VPWR VPWR sky130_fd_sc_hd__fill_1
Xhold2 hold2/A VGND VGND VPWR VPWR hold2/X sky130_fd_sc_hd__dlygate4sd3_1
X_3090_ _5677_/Q _5678_/Q _3089_/Y VGND VGND VPWR VPWR _5678_/D sky130_fd_sc_hd__o21a_1
XANTENNA__5094__A1 _5094_/A1 VGND VGND VPWR VPWR sky130_fd_sc_hd__diode_2
XANTENNA__5060__S _5123_/B VGND VGND VPWR VPWR sky130_fd_sc_hd__diode_2
XANTENNA__2852__B1 _2918_/B1 VGND VGND VPWR VPWR sky130_fd_sc_hd__diode_2
XFILLER_50_504 VGND VGND VPWR VPWR sky130_fd_sc_hd__fill_1
X_3992_ _3996_/A _3992_/B _3992_/C VGND VGND VPWR VPWR _5624_/D sky130_fd_sc_hd__and3_1
X_5800_ _6163_/CLK _5800_/D fanout325/X VGND VGND VPWR VPWR _5800_/Q sky130_fd_sc_hd__dfrtp_1
X_5731_ _5731_/CLK _5731_/D fanout305/X VGND VGND VPWR VPWR _5731_/Q sky130_fd_sc_hd__dfrtp_1
X_2943_ _6131_/Q _2908_/B _2933_/X _2942_/X VGND VGND VPWR VPWR _6131_/D sky130_fd_sc_hd__a22o_2
XTAP_TAPCELL_ROW_20_429 VGND VPWR sky130_fd_sc_hd__tapvpwrvgnd_1
X_5662_ _6113_/CLK _5662_/D VGND VGND VPWR VPWR hold82/A sky130_fd_sc_hd__dfxtp_1
X_2874_ _6080_/Q _2783_/B _2921_/A2 _6088_/Q VGND VGND VPWR VPWR _2874_/X sky130_fd_sc_hd__a22o_1
X_4613_ _5950_/Q _5766_/Q _4615_/S VGND VGND VPWR VPWR _4613_/X sky130_fd_sc_hd__mux2_1
X_5593_ _5682_/CLK _5593_/D fanout319/X VGND VGND VPWR VPWR _5593_/Q sky130_fd_sc_hd__dfrtp_1
X_4544_ _4544_/A _4825_/C VGND VGND VPWR VPWR _4544_/X sky130_fd_sc_hd__and2_1
Xhold402 _6024_/Q VGND VGND VPWR VPWR hold402/X sky130_fd_sc_hd__dlygate4sd3_1
Xhold424 _5948_/Q VGND VGND VPWR VPWR hold424/X sky130_fd_sc_hd__dlygate4sd3_1
Xhold435 _5951_/Q VGND VGND VPWR VPWR hold435/X sky130_fd_sc_hd__dlygate4sd3_1
Xhold413 _5986_/Q VGND VGND VPWR VPWR hold413/X sky130_fd_sc_hd__dlygate4sd3_1
Xhold468 _5911_/Q VGND VGND VPWR VPWR hold468/X sky130_fd_sc_hd__dlygate4sd3_1
Xhold446 _5918_/Q VGND VGND VPWR VPWR hold446/X sky130_fd_sc_hd__dlygate4sd3_1
X_4475_ _4487_/B _4475_/B VGND VGND VPWR VPWR _4475_/Y sky130_fd_sc_hd__nand2_1
Xhold457 _5962_/Q VGND VGND VPWR VPWR hold457/X sky130_fd_sc_hd__dlygate4sd3_1
XANTENNA__4359__B _4475_/B VGND VGND VPWR VPWR sky130_fd_sc_hd__diode_2
X_3426_ _3426_/A _5599_/Q _4083_/A _3426_/D VGND VGND VPWR VPWR _3434_/S sky130_fd_sc_hd__and4_4
Xhold479 hold84/A VGND VGND VPWR VPWR hold479/X sky130_fd_sc_hd__dlygate4sd3_1
XANTENNA_fanout294_A fanout298/X VGND VGND VPWR VPWR sky130_fd_sc_hd__diode_2
X_6145_ _6160_/CLK _6145_/D fanout310/X VGND VGND VPWR VPWR _6145_/Q sky130_fd_sc_hd__dfrtp_1
X_3357_ _3357_/A _3357_/B _3357_/C _3357_/D VGND VGND VPWR VPWR _3358_/C sky130_fd_sc_hd__or4_1
X_6076_ _6113_/CLK _6076_/D fanout337/X VGND VGND VPWR VPWR _6076_/Q sky130_fd_sc_hd__dfrtp_1
X_5027_ hold410/X _5027_/A2 _5026_/X VGND VGND VPWR VPWR _5959_/D sky130_fd_sc_hd__a21o_1
XFILLER_57_169 VGND VGND VPWR VPWR sky130_fd_sc_hd__fill_2
XANTENNA__5085__A1 _5468_/Q VGND VGND VPWR VPWR sky130_fd_sc_hd__diode_2
X_3288_ _3298_/A _6029_/Q VGND VGND VPWR VPWR _3333_/A sky130_fd_sc_hd__and2_1
XANTENNA__4375__A _4829_/C VGND VGND VPWR VPWR sky130_fd_sc_hd__diode_2
XTAP_TAPCELL_ROW_28_529 VGND VPWR sky130_fd_sc_hd__tapvpwrvgnd_1
XFILLER_53_331 VGND VGND VPWR VPWR sky130_fd_sc_hd__fill_1
XTAP_TAPCELL_ROW_0_165 VGND VPWR sky130_fd_sc_hd__tapvpwrvgnd_1
XTAP_TAPCELL_ROW_0_176 VGND VPWR sky130_fd_sc_hd__tapvpwrvgnd_1
XFILLER_13_206 VGND VGND VPWR VPWR sky130_fd_sc_hd__fill_1
XANTENNA__4596__B1 _4740_/B1 VGND VGND VPWR VPWR sky130_fd_sc_hd__diode_2
XFILLER_70_15 VPWR VGND VPWR VGND sky130_ef_sc_hd__decap_12
X_5929_ _6032_/CLK _5929_/D fanout299/X VGND VGND VPWR VPWR _5929_/Q sky130_fd_sc_hd__dfrtp_1
XFILLER_21_294 VGND VGND VPWR VPWR sky130_fd_sc_hd__fill_1
XANTENNA__4899__B2 _4898_/X VGND VGND VPWR VPWR sky130_fd_sc_hd__diode_2
XFILLER_5_449 VGND VGND VPWR VPWR sky130_fd_sc_hd__decap_8
XANTENNA__5145__S _5167_/S VGND VGND VPWR VPWR sky130_fd_sc_hd__diode_2
XFILLER_1_644 VPWR VGND VPWR VGND sky130_ef_sc_hd__decap_12
XTAP_TAPCELL_ROW_8_276 VGND VPWR sky130_fd_sc_hd__tapvpwrvgnd_1
XANTENNA__5076__A1 _5487_/Q VGND VGND VPWR VPWR sky130_fd_sc_hd__diode_2
XANTENNA__4823__A1 _4517_/A VGND VGND VPWR VPWR sky130_fd_sc_hd__diode_2
XFILLER_28_83 VGND VGND VPWR VPWR sky130_fd_sc_hd__fill_1
XANTENNA__5993__RESET_B fanout341/X VGND VGND VPWR VPWR sky130_fd_sc_hd__diode_2
XTAP_TAPCELL_ROW_55_871 VGND VPWR sky130_fd_sc_hd__tapvpwrvgnd_1
XANTENNA__4587__B1 _4740_/B1 VGND VGND VPWR VPWR sky130_fd_sc_hd__diode_2
XANTENNA__5922__RESET_B fanout307/X VGND VGND VPWR VPWR sky130_fd_sc_hd__diode_2
XFILLER_40_570 VGND VGND VPWR VPWR sky130_fd_sc_hd__decap_3
XANTENNA__4339__B1 _5458_/C VGND VGND VPWR VPWR sky130_fd_sc_hd__diode_2
XFILLER_60_81 VGND VGND VPWR VPWR sky130_fd_sc_hd__decap_3
XFILLER_8_265 VGND VGND VPWR VPWR sky130_fd_sc_hd__decap_8
XTAP_TAPCELL_ROW_74_1103 VGND VPWR sky130_fd_sc_hd__tapvpwrvgnd_1
XANTENNA__5055__S _5055_/S VGND VGND VPWR VPWR sky130_fd_sc_hd__diode_2
X_4260_ _5714_/Q _4250_/A _4250_/B _4093_/A VGND VGND VPWR VPWR _4260_/X sky130_fd_sc_hd__a22o_1
X_4191_ _4191_/A VGND VGND VPWR VPWR _4191_/Y sky130_fd_sc_hd__inv_2
X_3211_ _5612_/Q _3408_/B _3958_/B VGND VGND VPWR VPWR _3219_/S sky130_fd_sc_hd__and3_4
X_3142_ _5955_/Q _2971_/X _2973_/X _5963_/Q _2968_/X VGND VGND VPWR VPWR _3142_/X
+ sky130_fd_sc_hd__a221o_1
XFILLER_39_103 VGND VGND VPWR VPWR sky130_fd_sc_hd__decap_3
XANTENNA__3370__Y _4177_/C VGND VGND VPWR VPWR sky130_fd_sc_hd__diode_2
XFILLER_54_117 VGND VGND VPWR VPWR sky130_fd_sc_hd__decap_3
X_3073_ _3060_/Y _3061_/X _3063_/X _3064_/Y VGND VGND VPWR VPWR _3075_/C sky130_fd_sc_hd__a22o_1
XANTENNA__4814__A1 _4404_/A VGND VGND VPWR VPWR sky130_fd_sc_hd__diode_2
XFILLER_39_169 VPWR VGND VPWR VGND sky130_ef_sc_hd__decap_12
XFILLER_35_320 VGND VGND VPWR VPWR sky130_fd_sc_hd__fill_1
XFILLER_35_364 VPWR VGND VPWR VGND sky130_ef_sc_hd__decap_12
XANTENNA__4578__A0 _5489_/Q VGND VGND VPWR VPWR sky130_fd_sc_hd__diode_2
XFILLER_50_356 VGND VGND VPWR VPWR sky130_fd_sc_hd__fill_2
X_3975_ _3976_/A _4541_/S VGND VGND VPWR VPWR _3975_/Y sky130_fd_sc_hd__nor2_2
X_2926_ _6006_/Q _2910_/B _2926_/B1 _5998_/Q _2925_/X VGND VGND VPWR VPWR _2926_/X
+ sky130_fd_sc_hd__a221o_1
X_5714_ _5723_/CLK _5714_/D fanout293/X VGND VGND VPWR VPWR _5714_/Q sky130_fd_sc_hd__dfrtp_1
XANTENNA__4361__C _5737_/Q VGND VGND VPWR VPWR sky130_fd_sc_hd__diode_2
XTAP_TAPCELL_ROW_33_587 VGND VPWR sky130_fd_sc_hd__tapvpwrvgnd_1
X_2857_ _5817_/Q _2783_/X _2852_/X _2856_/X VGND VGND VPWR VPWR _2857_/X sky130_fd_sc_hd__a211o_1
X_5645_ _5645_/CLK hold7/X VGND VGND VPWR VPWR _5645_/Q sky130_fd_sc_hd__dfxtp_1
XPHY_EDGE_ROW_17_Left_98 VGND VGND VPWR VPWR sky130_fd_sc_hd__decap_3
XTAP_TAPCELL_ROW_33_598 VGND VPWR sky130_fd_sc_hd__tapvpwrvgnd_1
XANTENNA_fanout307_A fanout309/X VGND VGND VPWR VPWR sky130_fd_sc_hd__diode_2
Xhold210 _5840_/Q VGND VGND VPWR VPWR hold210/X sky130_fd_sc_hd__dlygate4sd3_1
X_2788_ _2864_/A _2920_/B _2925_/B VGND VGND VPWR VPWR _2788_/Y sky130_fd_sc_hd__nor3b_1
X_5576_ _5707_/CLK _5576_/D fanout291/X VGND VGND VPWR VPWR _5576_/Q sky130_fd_sc_hd__dfrtp_1
Xhold221 _5730_/Q VGND VGND VPWR VPWR hold221/X sky130_fd_sc_hd__dlygate4sd3_1
Xhold232 _5830_/Q VGND VGND VPWR VPWR hold232/X sky130_fd_sc_hd__dlygate4sd3_1
Xhold243 _6071_/Q VGND VGND VPWR VPWR hold243/X sky130_fd_sc_hd__dlygate4sd3_1
X_4527_ _4524_/X _4526_/X _4527_/S VGND VGND VPWR VPWR _4527_/X sky130_fd_sc_hd__mux2_1
Xhold265 _5881_/Q VGND VGND VPWR VPWR hold265/X sky130_fd_sc_hd__dlygate4sd3_1
Xhold287 _6073_/Q VGND VGND VPWR VPWR hold287/X sky130_fd_sc_hd__dlygate4sd3_1
Xhold276 _5871_/Q VGND VGND VPWR VPWR hold276/X sky130_fd_sc_hd__dlygate4sd3_1
Xhold254 _5888_/Q VGND VGND VPWR VPWR hold254/X sky130_fd_sc_hd__dlygate4sd3_1
X_4458_ _4454_/Y _4455_/X _4457_/X VGND VGND VPWR VPWR _4462_/B sky130_fd_sc_hd__a21o_1
Xhold298 _5874_/Q VGND VGND VPWR VPWR hold298/X sky130_fd_sc_hd__dlygate4sd3_1
X_3409_ hold41/X _5635_/Q _3416_/S VGND VGND VPWR VPWR hold42/A sky130_fd_sc_hd__mux2_1
XFILLER_58_434 VGND VGND VPWR VPWR sky130_fd_sc_hd__fill_1
X_6128_ _6131_/CLK _6128_/D fanout328/X VGND VGND VPWR VPWR _6128_/Q sky130_fd_sc_hd__dfstp_1
XTAP_TAPCELL_ROW_5_246 VGND VPWR sky130_fd_sc_hd__tapvpwrvgnd_1
X_4389_ _4408_/A _4452_/B VGND VGND VPWR VPWR _4390_/B sky130_fd_sc_hd__nor2_1
XANTENNA__5058__A1 _5397_/A VGND VGND VPWR VPWR sky130_fd_sc_hd__diode_2
XANTENNA__4309__S _5458_/C VGND VGND VPWR VPWR sky130_fd_sc_hd__diode_2
XANTENNA__3213__S _3219_/S VGND VGND VPWR VPWR sky130_fd_sc_hd__diode_2
X_6059_ _6061_/CLK _6059_/D fanout283/X VGND VGND VPWR VPWR _6059_/Q sky130_fd_sc_hd__dfrtp_1
XFILLER_18_309 VGND VGND VPWR VPWR sky130_fd_sc_hd__fill_1
XFILLER_39_670 VGND VGND VPWR VPWR sky130_fd_sc_hd__fill_2
XTAP_TAPCELL_ROW_52_830 VGND VPWR sky130_fd_sc_hd__tapvpwrvgnd_1
XANTENNA__3792__A1 _6167_/Q VGND VGND VPWR VPWR sky130_fd_sc_hd__diode_2
XANTENNA__4741__A0 _5766_/Q VGND VGND VPWR VPWR sky130_fd_sc_hd__diode_2
XFILLER_5_279 VGND VGND VPWR VPWR sky130_fd_sc_hd__fill_1
XANTENNA__3184__A _5599_/Q VGND VGND VPWR VPWR sky130_fd_sc_hd__diode_2
XFILLER_1_441 VGND VGND VPWR VPWR sky130_fd_sc_hd__decap_6
XFILLER_76_253 VGND VGND VPWR VPWR sky130_fd_sc_hd__fill_1
XFILLER_29_191 VGND VGND VPWR VPWR sky130_fd_sc_hd__decap_8
XFILLER_45_673 VGND VGND VPWR VPWR sky130_fd_sc_hd__fill_1
XFILLER_60_643 VGND VGND VPWR VPWR sky130_fd_sc_hd__fill_1
X_3760_ _3887_/A _5849_/Q VGND VGND VPWR VPWR _3760_/X sky130_fd_sc_hd__and2_1
XTAP_TAPCELL_ROW_80_1195 VGND VPWR sky130_fd_sc_hd__tapvpwrvgnd_1
XTAP_TAPCELL_ROW_80_1184 VGND VPWR sky130_fd_sc_hd__tapvpwrvgnd_1
X_3691_ _3713_/B _3713_/C _3691_/C _3714_/D VGND VGND VPWR VPWR _3691_/X sky130_fd_sc_hd__or4_1
XTAP_TAPCELL_ROW_30_557 VGND VPWR sky130_fd_sc_hd__tapvpwrvgnd_1
X_5430_ _5430_/A _5430_/B VGND VGND VPWR VPWR _5430_/X sky130_fd_sc_hd__or2_1
XFILLER_65_3 VGND VGND VPWR VPWR sky130_fd_sc_hd__fill_2
XANTENNA__4732__B1 _5123_/B VGND VGND VPWR VPWR sky130_fd_sc_hd__diode_2
X_5361_ _5362_/B _5362_/C _6163_/Q VGND VGND VPWR VPWR _5361_/X sky130_fd_sc_hd__o21a_1
X_4312_ _5717_/Q _4311_/X _4312_/S VGND VGND VPWR VPWR _5717_/D sky130_fd_sc_hd__mux2_1
X_5292_ _6152_/Q _5343_/B VGND VGND VPWR VPWR _5293_/B sky130_fd_sc_hd__or2_1
X_4243_ _4242_/X _4241_/X _4243_/S VGND VGND VPWR VPWR _4243_/X sky130_fd_sc_hd__mux2_1
X_4174_ _4175_/A _4876_/A _5369_/A _4175_/D VGND VGND VPWR VPWR _4174_/X sky130_fd_sc_hd__or4_1
X_3125_ _3121_/X _3122_/X _3124_/X _2965_/X VGND VGND VPWR VPWR _3126_/B sky130_fd_sc_hd__o211ai_2
XTAP_TAPCELL_ROW_2_205 VGND VPWR sky130_fd_sc_hd__tapvpwrvgnd_1
XANTENNA__4799__A0 _5471_/Q VGND VGND VPWR VPWR sky130_fd_sc_hd__diode_2
X_3056_ _5623_/Q _3056_/B _5626_/Q _5624_/Q VGND VGND VPWR VPWR _5643_/D sky130_fd_sc_hd__or4bb_1
XTAP_TAPCELL_ROW_38_657 VGND VPWR sky130_fd_sc_hd__tapvpwrvgnd_1
XANTENNA_fanout257_A _5727_/Q VGND VGND VPWR VPWR sky130_fd_sc_hd__diode_2
XTAP_TAPCELL_ROW_66_999 VGND VPWR sky130_fd_sc_hd__tapvpwrvgnd_1
XFILLER_35_161 VGND VGND VPWR VPWR sky130_fd_sc_hd__fill_1
XANTENNA__3223__A0 _2843_/B VGND VGND VPWR VPWR sky130_fd_sc_hd__diode_2
X_3958_ _5612_/Q _3958_/B VGND VGND VPWR VPWR _3959_/B sky130_fd_sc_hd__nor2_1
X_2909_ _5718_/Q _5067_/B _2901_/X _2907_/X _2908_/X VGND VGND VPWR VPWR _6130_/D
+ sky130_fd_sc_hd__a41o_2
X_3889_ _5447_/A _3902_/A2 _3888_/X VGND VGND VPWR VPWR _3889_/X sky130_fd_sc_hd__o21a_1
XANTENNA__2982__C1 _2977_/Y VGND VGND VPWR VPWR sky130_fd_sc_hd__diode_2
X_5628_ _5645_/CLK hold10/X VGND VGND VPWR VPWR hold8/A sky130_fd_sc_hd__dfxtp_1
XANTENNA__4723__B1 _4747_/B1 VGND VGND VPWR VPWR sky130_fd_sc_hd__diode_2
X_5559_ _5696_/CLK _5559_/D VGND VGND VPWR VPWR hold59/A sky130_fd_sc_hd__dfxtp_1
XANTENNA__3829__A2 _4175_/D VGND VGND VPWR VPWR sky130_fd_sc_hd__diode_2
XFILLER_76_25 VGND VGND VPWR VPWR sky130_fd_sc_hd__decap_3
XANTENNA_fanout72_A _4166_/C VGND VGND VPWR VPWR sky130_fd_sc_hd__diode_2
XFILLER_14_312 VGND VGND VPWR VPWR sky130_fd_sc_hd__decap_8
XFILLER_26_194 VGND VGND VPWR VPWR sky130_fd_sc_hd__fill_2
XFILLER_41_164 VGND VGND VPWR VPWR sky130_fd_sc_hd__decap_4
XFILLER_10_595 VGND VGND VPWR VPWR sky130_fd_sc_hd__fill_1
XANTENNA__4714__A0 _5796_/Q VGND VGND VPWR VPWR sky130_fd_sc_hd__diode_2
XFILLER_49_242 VGND VGND VPWR VPWR sky130_fd_sc_hd__fill_1
XFILLER_1_293 VPWR VGND VPWR VGND sky130_ef_sc_hd__decap_12
XFILLER_2_77 VGND VGND VPWR VPWR sky130_fd_sc_hd__decap_6
XANTENNA__4176__C _4176_/C VGND VGND VPWR VPWR sky130_fd_sc_hd__diode_2
XTAP_TAPCELL_ROW_69_1046 VGND VPWR sky130_fd_sc_hd__tapvpwrvgnd_1
X_4930_ hold432/X _4948_/A2 _4929_/X VGND VGND VPWR VPWR _5919_/D sky130_fd_sc_hd__a21o_1
XFILLER_18_673 VGND VGND VPWR VPWR sky130_fd_sc_hd__fill_1
XTAP_TAPCELL_ROW_35_616 VGND VPWR sky130_fd_sc_hd__tapvpwrvgnd_1
X_4861_ _4964_/A0 hold303/X _4864_/S VGND VGND VPWR VPWR _5895_/D sky130_fd_sc_hd__mux2_1
XTAP_TAPCELL_ROW_63_969 VGND VPWR sky130_fd_sc_hd__tapvpwrvgnd_1
XANTENNA__3205__A0 _4967_/A0 VGND VGND VPWR VPWR sky130_fd_sc_hd__diode_2
X_3812_ _5572_/Q _3798_/X _3758_/S VGND VGND VPWR VPWR _3812_/Y sky130_fd_sc_hd__o21ai_1
XTAP_TAPCELL_ROW_15_362 VGND VPWR sky130_fd_sc_hd__tapvpwrvgnd_1
XPHY_EDGE_ROW_25_Left_106 VGND VGND VPWR VPWR sky130_fd_sc_hd__decap_3
X_4792_ _5492_/Q hold308/X _4810_/S VGND VGND VPWR VPWR _5829_/D sky130_fd_sc_hd__mux2_1
XTAP_TAPCELL_ROW_15_373 VGND VPWR sky130_fd_sc_hd__tapvpwrvgnd_1
XFILLER_20_337 VPWR VGND VPWR VGND sky130_ef_sc_hd__decap_12
XFILLER_32_175 VPWR VGND VPWR VGND sky130_ef_sc_hd__decap_12
X_3743_ _3740_/Y _3741_/X _4113_/B _3916_/S VGND VGND VPWR VPWR _3743_/X sky130_fd_sc_hd__a22o_1
XFILLER_9_393 VPWR VGND VPWR VGND sky130_ef_sc_hd__decap_12
X_3674_ _3674_/A _3674_/B VGND VGND VPWR VPWR _3674_/Y sky130_fd_sc_hd__nor2_1
X_5413_ _6170_/Q _5427_/B VGND VGND VPWR VPWR _5414_/B sky130_fd_sc_hd__nor2_1
X_5344_ _5338_/A _5339_/X _5343_/X VGND VGND VPWR VPWR _5344_/Y sky130_fd_sc_hd__o21ai_1
XPHY_EDGE_ROW_34_Left_115 VGND VGND VPWR VPWR sky130_fd_sc_hd__decap_3
X_5275_ _5270_/A _5270_/B _5268_/A VGND VGND VPWR VPWR _5276_/B sky130_fd_sc_hd__a21o_1
X_4226_ _4225_/X _4223_/X _4226_/S VGND VGND VPWR VPWR _4227_/B sky130_fd_sc_hd__mux2_1
X_4157_ _4157_/A _4157_/B _4157_/C VGND VGND VPWR VPWR _5699_/D sky130_fd_sc_hd__and3_1
X_3108_ hold36/A hold44/A _3954_/A VGND VGND VPWR VPWR _3109_/B sky130_fd_sc_hd__mux2_1
X_4088_ _5586_/Q hold76/X _4091_/S VGND VGND VPWR VPWR _5695_/D sky130_fd_sc_hd__mux2_1
XANTENNA__5433__A1 _5427_/A VGND VGND VPWR VPWR sky130_fd_sc_hd__diode_2
XANTENNA_fanout162_X _4232_/S VGND VGND VPWR VPWR sky130_fd_sc_hd__diode_2
X_3039_ _5934_/Q _3144_/B _2980_/Y _5943_/Q _2977_/Y VGND VGND VPWR VPWR _3039_/X
+ sky130_fd_sc_hd__a221o_1
XANTENNA__4383__A _4829_/C VGND VGND VPWR VPWR sky130_fd_sc_hd__diode_2
XFILLER_62_27 VGND VGND VPWR VPWR sky130_fd_sc_hd__fill_1
XPHY_EDGE_ROW_43_Left_124 VGND VGND VPWR VPWR sky130_fd_sc_hd__decap_3
XFILLER_51_473 VGND VGND VPWR VPWR sky130_fd_sc_hd__fill_2
XFILLER_24_698 VGND VGND VPWR VPWR sky130_fd_sc_hd__fill_2
XFILLER_51_484 VPWR VGND VPWR VGND sky130_ef_sc_hd__decap_12
XANTENNA__4944__B1 _4878_/B VGND VGND VPWR VPWR sky130_fd_sc_hd__diode_2
XFILLER_3_503 VGND VGND VPWR VPWR sky130_fd_sc_hd__fill_1
XPHY_EDGE_ROW_52_Left_133 VGND VGND VPWR VPWR sky130_fd_sc_hd__decap_3
XFILLER_11_75 VGND VGND VPWR VPWR sky130_fd_sc_hd__fill_1
XANTENNA__5153__S _5167_/S VGND VGND VPWR VPWR sky130_fd_sc_hd__diode_2
Xfanout350 fanout351/X VGND VGND VPWR VPWR fanout350/X sky130_fd_sc_hd__clkbuf_2
XANTENNA_fanout75_X _4544_/A VGND VGND VPWR VPWR sky130_fd_sc_hd__diode_2
XPHY_EDGE_ROW_61_Left_142 VGND VGND VPWR VPWR sky130_fd_sc_hd__decap_3
XANTENNA__3401__S _3407_/S VGND VGND VPWR VPWR sky130_fd_sc_hd__diode_2
XANTENNA__4632__C1 _4720_/C1 VGND VGND VPWR VPWR sky130_fd_sc_hd__diode_2
XTAP_TAPCELL_ROW_60_928 VGND VPWR sky130_fd_sc_hd__tapvpwrvgnd_1
XFILLER_14_164 VPWR VGND VPWR VGND sky130_ef_sc_hd__decap_12
XFILLER_14_197 VGND VGND VPWR VPWR sky130_fd_sc_hd__decap_4
XANTENNA__4935__B1 _4950_/B1 VGND VGND VPWR VPWR sky130_fd_sc_hd__diode_2
XFILLER_52_71 VGND VGND VPWR VPWR sky130_fd_sc_hd__decap_3
XTAP_TAPCELL_ROW_12_332 VGND VPWR sky130_fd_sc_hd__tapvpwrvgnd_1
XANTENNA__4232__S _4232_/S VGND VGND VPWR VPWR sky130_fd_sc_hd__diode_2
XTAP_TAPCELL_ROW_40_674 VGND VPWR sky130_fd_sc_hd__tapvpwrvgnd_1
XTAP_TAPCELL_ROW_40_685 VGND VPWR sky130_fd_sc_hd__tapvpwrvgnd_1
XPHY_EDGE_ROW_70_Left_151 VGND VGND VPWR VPWR sky130_fd_sc_hd__decap_3
XFILLER_6_330 VGND VGND VPWR VPWR sky130_fd_sc_hd__fill_2
XFILLER_6_363 VGND VGND VPWR VPWR sky130_fd_sc_hd__fill_1
X_3390_ _5988_/Q _6032_/Q _3749_/A VGND VGND VPWR VPWR _3390_/X sky130_fd_sc_hd__mux2_1
XANTENNA__5063__S _5066_/S VGND VGND VPWR VPWR sky130_fd_sc_hd__diode_2
XFILLER_69_348 VGND VGND VPWR VPWR sky130_fd_sc_hd__fill_1
X_5060_ _5984_/Q _6170_/Q _5123_/B VGND VGND VPWR VPWR _5984_/D sky130_fd_sc_hd__mux2_1
X_4011_ _4014_/A _5649_/Q hold11/A VGND VGND VPWR VPWR _4011_/Y sky130_fd_sc_hd__a21oi_1
XFILLER_28_3 VPWR VGND VPWR VGND sky130_ef_sc_hd__decap_12
XTAP_TAPCELL_ROW_48_785 VGND VPWR sky130_fd_sc_hd__tapvpwrvgnd_1
XTAP_TAPCELL_ROW_48_774 VGND VPWR sky130_fd_sc_hd__tapvpwrvgnd_1
X_5962_ _6032_/CLK _5962_/D fanout300/X VGND VGND VPWR VPWR _5962_/Q sky130_fd_sc_hd__dfrtp_1
X_4913_ _5490_/Q _4586_/X _4949_/S VGND VGND VPWR VPWR _4913_/X sky130_fd_sc_hd__mux2_1
XFILLER_18_492 VGND VGND VPWR VPWR sky130_fd_sc_hd__fill_2
X_5893_ _6021_/CLK _5893_/D fanout333/X VGND VGND VPWR VPWR _5893_/Q sky130_fd_sc_hd__dfrtp_1
X_4844_ _5490_/Q hold296/X _4864_/S VGND VGND VPWR VPWR _5878_/D sky130_fd_sc_hd__mux2_1
XFILLER_33_484 VGND VGND VPWR VPWR sky130_fd_sc_hd__fill_1
XANTENNA__4926__B1 _4950_/B1 VGND VGND VPWR VPWR sky130_fd_sc_hd__diode_2
XFILLER_21_679 VGND VGND VPWR VPWR sky130_fd_sc_hd__decap_8
X_4775_ hold173/X _3889_/X _4776_/S VGND VGND VPWR VPWR _5813_/D sky130_fd_sc_hd__mux2_1
XANTENNA_fanout122_A _5026_/B1 VGND VGND VPWR VPWR sky130_fd_sc_hd__diode_2
XFILLER_20_167 VGND VGND VPWR VPWR sky130_fd_sc_hd__decap_8
XFILLER_20_189 VGND VGND VPWR VPWR sky130_fd_sc_hd__decap_6
X_3726_ _3725_/A _3905_/B _3725_/C _5719_/Q VGND VGND VPWR VPWR _3726_/X sky130_fd_sc_hd__o31a_1
X_3657_ _4399_/A _6035_/Q VGND VGND VPWR VPWR _3697_/C sky130_fd_sc_hd__nor2_1
X_3588_ _4873_/A _4873_/B _3707_/B _3709_/B VGND VGND VPWR VPWR _3593_/C sky130_fd_sc_hd__or4_1
X_5327_ _5325_/X _5327_/B _5327_/C VGND VGND VPWR VPWR _5327_/X sky130_fd_sc_hd__and3b_1
X_5258_ _5258_/A _5258_/B VGND VGND VPWR VPWR _5258_/Y sky130_fd_sc_hd__xnor2_1
X_4209_ _4209_/A _4209_/B VGND VGND VPWR VPWR _4209_/X sky130_fd_sc_hd__or2_1
X_5189_ _6110_/Q _5189_/A2 _3268_/B _4551_/B VGND VGND VPWR VPWR _6110_/D sky130_fd_sc_hd__a22o_1
XFILLER_73_15 VGND VGND VPWR VPWR sky130_fd_sc_hd__fill_1
XANTENNA__4614__C1 _4678_/C1 VGND VGND VPWR VPWR sky130_fd_sc_hd__diode_2
XFILLER_24_451 VGND VGND VPWR VPWR sky130_fd_sc_hd__decap_8
XFILLER_12_657 VGND VGND VPWR VPWR sky130_fd_sc_hd__decap_3
XFILLER_7_105 VGND VGND VPWR VPWR sky130_fd_sc_hd__decap_6
XANTENNA__5148__S _5172_/S VGND VGND VPWR VPWR sky130_fd_sc_hd__diode_2
XFILLER_8_639 VGND VGND VPWR VPWR sky130_fd_sc_hd__decap_4
XANTENNA__4052__S _4052_/S VGND VGND VPWR VPWR sky130_fd_sc_hd__diode_2
XPHY_EDGE_ROW_5_Left_86 VGND VGND VPWR VPWR sky130_fd_sc_hd__decap_3
Xfanout191 _6169_/Q VGND VGND VPWR VPWR _5406_/A sky130_fd_sc_hd__buf_2
XTAP_TAPCELL_ROW_66_1005 VGND VPWR sky130_fd_sc_hd__tapvpwrvgnd_1
XTAP_TAPCELL_ROW_45_744 VGND VPWR sky130_fd_sc_hd__tapvpwrvgnd_1
XFILLER_63_70 VGND VGND VPWR VPWR sky130_fd_sc_hd__fill_1
XANTENNA__4620__A2 _4684_/A2 VGND VGND VPWR VPWR sky130_fd_sc_hd__diode_2
X_2890_ _5846_/Q _2886_/B _2926_/B1 _5822_/Q VGND VGND VPWR VPWR _2890_/X sky130_fd_sc_hd__a22o_1
XFILLER_30_421 VPWR VGND VPWR VGND sky130_ef_sc_hd__decap_12
XANTENNA__4908__B1 _4950_/B1 VGND VGND VPWR VPWR sky130_fd_sc_hd__diode_2
XTAP_TAPCELL_ROW_25_490 VGND VPWR sky130_fd_sc_hd__tapvpwrvgnd_1
XFILLER_30_465 VGND VGND VPWR VPWR sky130_fd_sc_hd__decap_3
XFILLER_8_76 VGND VGND VPWR VPWR sky130_fd_sc_hd__fill_2
XANTENNA__5058__S _5066_/S VGND VGND VPWR VPWR sky130_fd_sc_hd__diode_2
X_4560_ hold417/X _2837_/B _4829_/B VGND VGND VPWR VPWR _5768_/D sky130_fd_sc_hd__a21o_1
XTAP_TAPCELL_ROW_77_1145 VGND VPWR sky130_fd_sc_hd__tapvpwrvgnd_1
XFILLER_6_171 VPWR VGND VPWR VGND sky130_ef_sc_hd__decap_12
X_4491_ _4491_/A _4530_/B VGND VGND VPWR VPWR _4491_/Y sky130_fd_sc_hd__xnor2_1
X_3511_ _3538_/A _3545_/B VGND VGND VPWR VPWR _3511_/Y sky130_fd_sc_hd__nor2_1
X_3442_ hold55/X _5589_/Q _3442_/S VGND VGND VPWR VPWR _5556_/D sky130_fd_sc_hd__mux2_1
X_6161_ _6161_/CLK _6161_/D fanout311/X VGND VGND VPWR VPWR _6161_/Q sky130_fd_sc_hd__dfrtp_1
X_3373_ hold150/X _3397_/A2 _4544_/A _3372_/X VGND VGND VPWR VPWR _5504_/D sky130_fd_sc_hd__a22o_1
X_5112_ hold330/X _4404_/A _5116_/S VGND VGND VPWR VPWR _6035_/D sky130_fd_sc_hd__mux2_1
X_6092_ _6092_/CLK _6092_/D fanout339/X VGND VGND VPWR VPWR _6092_/Q sky130_fd_sc_hd__dfrtp_1
X_5043_ hold460/X _5043_/A2 _5042_/X VGND VGND VPWR VPWR _5967_/D sky130_fd_sc_hd__a21o_1
XFILLER_38_587 VGND VGND VPWR VPWR sky130_fd_sc_hd__fill_1
XFILLER_38_598 VGND VGND VPWR VPWR sky130_fd_sc_hd__decap_3
XFILLER_80_365 VGND VGND VPWR VPWR sky130_fd_sc_hd__decap_6
X_5945_ _6142_/CLK _5945_/D fanout326/X VGND VGND VPWR VPWR _5945_/Q sky130_fd_sc_hd__dfrtp_1
XANTENNA_fanout337_A fanout341/X VGND VGND VPWR VPWR sky130_fd_sc_hd__diode_2
X_5876_ _6092_/CLK _5876_/D fanout339/X VGND VGND VPWR VPWR _5876_/Q sky130_fd_sc_hd__dfrtp_1
XFILLER_33_281 VGND VGND VPWR VPWR sky130_fd_sc_hd__decap_8
XANTENNA__3548__Y _3548_/Y VGND VGND VPWR VPWR sky130_fd_sc_hd__diode_2
X_4827_ hold389/X _2964_/B _3254_/A _4870_/A1 VGND VGND VPWR VPWR _5862_/D sky130_fd_sc_hd__a22o_1
X_4758_ _5797_/Q _5174_/A2 _4561_/B _3544_/X VGND VGND VPWR VPWR _5797_/D sky130_fd_sc_hd__a22o_1
XANTENNA_fanout125_X _4878_/B VGND VGND VPWR VPWR sky130_fd_sc_hd__diode_2
X_4689_ hold235/X _4753_/A2 _4688_/X VGND VGND VPWR VPWR _5784_/D sky130_fd_sc_hd__o21a_1
X_3709_ _3709_/A _3709_/B _3709_/C _3709_/D VGND VGND VPWR VPWR _3710_/D sky130_fd_sc_hd__or4_1
XANTENNA__3216__S _3219_/S VGND VGND VPWR VPWR sky130_fd_sc_hd__diode_2
XFILLER_48_307 VGND VGND VPWR VPWR sky130_fd_sc_hd__fill_1
XFILLER_71_376 VGND VGND VPWR VPWR sky130_fd_sc_hd__decap_8
XANTENNA_fanout38_X _4829_/B VGND VGND VPWR VPWR sky130_fd_sc_hd__diode_2
XTAP_TAPCELL_ROW_42_703 VGND VPWR sky130_fd_sc_hd__tapvpwrvgnd_1
XANTENNA__6146__RESET_B fanout310/X VGND VGND VPWR VPWR sky130_fd_sc_hd__diode_2
XFILLER_12_443 VPWR VGND VPWR VGND sky130_ef_sc_hd__decap_12
XANTENNA__3169__A2 _5472_/Q VGND VGND VPWR VPWR sky130_fd_sc_hd__diode_2
XTAP_TAPCELL_ROW_22_460 VGND VPWR sky130_fd_sc_hd__tapvpwrvgnd_1
XFILLER_12_498 VGND VGND VPWR VPWR sky130_fd_sc_hd__fill_2
XFILLER_4_642 VGND VGND VPWR VPWR sky130_fd_sc_hd__fill_2
Xtt_um_bfcpu_364 VGND VGND VPWR VPWR tt_um_bfcpu_364/HI uo_out[2] sky130_fd_sc_hd__conb_1
Xtt_um_bfcpu_353 VGND VGND VPWR VPWR tt_um_bfcpu_353/HI uio_oe[0] sky130_fd_sc_hd__conb_1
XFILLER_4_697 VGND VGND VPWR VPWR sky130_fd_sc_hd__decap_3
XANTENNA__3877__A0 _6174_/Q VGND VGND VPWR VPWR sky130_fd_sc_hd__diode_2
XTAP_TAPCELL_ROW_72_1086 VGND VPWR sky130_fd_sc_hd__tapvpwrvgnd_1
XTAP_TAPCELL_ROW_72_1075 VGND VPWR sky130_fd_sc_hd__tapvpwrvgnd_1
XFILLER_66_104 VGND VGND VPWR VPWR sky130_fd_sc_hd__fill_1
Xhold3 hold3/A VGND VGND VPWR VPWR hold3/X sky130_fd_sc_hd__dlygate4sd3_1
XANTENNA__2818__X _3240_/A VGND VGND VPWR VPWR sky130_fd_sc_hd__diode_2
XFILLER_75_671 VGND VGND VPWR VPWR sky130_fd_sc_hd__fill_1
XANTENNA_clkbuf_leaf_11_clk_A clkbuf_leaf_9_clk/A VGND VGND VPWR VPWR sky130_fd_sc_hd__diode_2
XFILLER_47_351 VGND VGND VPWR VPWR sky130_fd_sc_hd__fill_1
X_3991_ _5624_/Q _5623_/Q _4005_/S VGND VGND VPWR VPWR _3992_/C sky130_fd_sc_hd__nand3_1
X_5730_ _5730_/CLK _5730_/D fanout304/X VGND VGND VPWR VPWR _5730_/Q sky130_fd_sc_hd__dfrtp_1
XANTENNA_clkbuf_leaf_26_clk_A clkload2/A VGND VGND VPWR VPWR sky130_fd_sc_hd__diode_2
X_2942_ _2837_/X _2941_/X _2908_/B VGND VGND VPWR VPWR _2942_/X sky130_fd_sc_hd__o21ba_1
XFILLER_15_281 VGND VGND VPWR VPWR sky130_fd_sc_hd__fill_1
X_2873_ _6092_/Q _2886_/B _2921_/B1 _6068_/Q VGND VGND VPWR VPWR _2873_/X sky130_fd_sc_hd__a22o_1
XFILLER_30_273 VGND VGND VPWR VPWR sky130_fd_sc_hd__decap_3
X_5661_ _6113_/CLK _5661_/D VGND VGND VPWR VPWR hold88/A sky130_fd_sc_hd__dfxtp_1
X_4612_ _5917_/Q _4684_/A2 _4684_/B1 _4611_/X VGND VGND VPWR VPWR _4612_/X sky130_fd_sc_hd__a211o_1
X_5592_ _6120_/CLK _5592_/D fanout319/X VGND VGND VPWR VPWR _5592_/Q sky130_fd_sc_hd__dfrtp_1
X_4543_ _4943_/S _4761_/A2 _3254_/A _4561_/B VGND VGND VPWR VPWR _5753_/D sky130_fd_sc_hd__a22o_1
Xhold425 _5930_/Q VGND VGND VPWR VPWR hold425/X sky130_fd_sc_hd__dlygate4sd3_1
Xhold414 _5958_/Q VGND VGND VPWR VPWR hold414/X sky130_fd_sc_hd__dlygate4sd3_1
Xmax_cap133 _4277_/S VGND VGND VPWR VPWR _4307_/S sky130_fd_sc_hd__clkbuf_2
Xhold403 _6151_/Q VGND VGND VPWR VPWR hold403/X sky130_fd_sc_hd__dlygate4sd3_1
Xhold436 _6027_/Q VGND VGND VPWR VPWR hold436/X sky130_fd_sc_hd__dlygate4sd3_1
Xhold447 _5963_/Q VGND VGND VPWR VPWR hold447/X sky130_fd_sc_hd__dlygate4sd3_1
Xhold458 _6157_/Q VGND VGND VPWR VPWR hold458/X sky130_fd_sc_hd__dlygate4sd3_1
X_4474_ _4487_/A _4357_/B _4473_/X VGND VGND VPWR VPWR _5745_/D sky130_fd_sc_hd__a21o_1
Xhold469 _5989_/Q VGND VGND VPWR VPWR hold469/X sky130_fd_sc_hd__dlygate4sd3_1
X_3425_ _5642_/Q hold32/X _3961_/A VGND VGND VPWR VPWR _5540_/D sky130_fd_sc_hd__mux2_1
X_6144_ _6144_/CLK _6144_/D fanout352/X VGND VGND VPWR VPWR _6144_/Q sky130_fd_sc_hd__dfrtp_1
X_3356_ _3356_/A _3356_/B _3356_/C _3356_/D VGND VGND VPWR VPWR _3358_/B sky130_fd_sc_hd__or4_1
X_6075_ _6093_/CLK _6075_/D fanout343/X VGND VGND VPWR VPWR _6075_/Q sky130_fd_sc_hd__dfrtp_1
X_3287_ _6034_/Q _3905_/A VGND VGND VPWR VPWR _3355_/D sky130_fd_sc_hd__and2b_1
X_5026_ _4685_/X _5026_/A2 _5026_/B1 _4949_/X VGND VGND VPWR VPWR _5026_/X sky130_fd_sc_hd__a22o_1
XANTENNA_fanout287_A input1/X VGND VGND VPWR VPWR sky130_fd_sc_hd__diode_2
XTAP_TAPCELL_ROW_0_166 VGND VPWR sky130_fd_sc_hd__tapvpwrvgnd_1
XTAP_TAPCELL_ROW_0_177 VGND VPWR sky130_fd_sc_hd__tapvpwrvgnd_1
X_5928_ _6110_/CLK _5928_/D fanout301/X VGND VGND VPWR VPWR _5928_/Q sky130_fd_sc_hd__dfrtp_1
XFILLER_80_195 VGND VGND VPWR VPWR sky130_fd_sc_hd__fill_1
XFILLER_70_27 VGND VGND VPWR VPWR sky130_fd_sc_hd__fill_1
X_5859_ _6026_/CLK _5859_/D fanout277/X VGND VGND VPWR VPWR _5859_/Q sky130_fd_sc_hd__dfrtp_1
XFILLER_21_273 VGND VGND VPWR VPWR sky130_fd_sc_hd__fill_1
XFILLER_5_417 VPWR VGND VPWR VGND sky130_ef_sc_hd__decap_12
XFILLER_49_605 VGND VGND VPWR VPWR sky130_fd_sc_hd__fill_1
XTAP_TAPCELL_ROW_8_277 VGND VPWR sky130_fd_sc_hd__tapvpwrvgnd_1
XFILLER_1_656 VPWR VGND VPWR VGND sky130_ef_sc_hd__decap_12
XANTENNA__5161__S _5167_/S VGND VGND VPWR VPWR sky130_fd_sc_hd__diode_2
XFILLER_0_199 VPWR VGND VPWR VGND sky130_ef_sc_hd__decap_12
XFILLER_17_502 VGND VGND VPWR VPWR sky130_fd_sc_hd__fill_2
XFILLER_44_332 VGND VGND VPWR VPWR sky130_fd_sc_hd__fill_1
XANTENNA__4587__A1 _4667_/B1 VGND VGND VPWR VPWR sky130_fd_sc_hd__diode_2
XTAP_TAPCELL_ROW_55_872 VGND VPWR sky130_fd_sc_hd__tapvpwrvgnd_1
XANTENNA__5397__A _5397_/A VGND VGND VPWR VPWR sky130_fd_sc_hd__diode_2
XFILLER_44_387 VGND VGND VPWR VPWR sky130_fd_sc_hd__fill_1
XFILLER_44_83 VGND VGND VPWR VPWR sky130_fd_sc_hd__fill_1
XFILLER_12_251 VGND VGND VPWR VPWR sky130_fd_sc_hd__fill_1
XFILLER_12_295 VPWR VGND VPWR VGND sky130_ef_sc_hd__decap_12
XFILLER_67_7 VGND VGND VPWR VPWR sky130_fd_sc_hd__fill_1
XANTENNA__5000__A2 _5024_/A2 VGND VGND VPWR VPWR sky130_fd_sc_hd__diode_2
XTAP_TAPCELL_ROW_74_1104 VGND VPWR sky130_fd_sc_hd__tapvpwrvgnd_1
X_4190_ _4190_/A _4190_/B VGND VGND VPWR VPWR _4191_/A sky130_fd_sc_hd__or2_1
X_3210_ _5612_/Q _3958_/B VGND VGND VPWR VPWR _3960_/B sky130_fd_sc_hd__and2_1
X_3141_ _3141_/A _3141_/B VGND VGND VPWR VPWR _6139_/D sky130_fd_sc_hd__nand2_1
XANTENNA__5071__S _5097_/S VGND VGND VPWR VPWR sky130_fd_sc_hd__diode_2
XFILLER_10_3 VPWR VGND VPWR VGND sky130_ef_sc_hd__decap_12
X_3072_ _5607_/Q _5656_/Q VGND VGND VPWR VPWR _3072_/X sky130_fd_sc_hd__xor2_1
XFILLER_23_505 VGND VGND VPWR VPWR sky130_fd_sc_hd__decap_8
XFILLER_35_376 VGND VGND VPWR VPWR sky130_fd_sc_hd__decap_6
XANTENNA__2724__A _5492_/Q VGND VGND VPWR VPWR sky130_fd_sc_hd__diode_2
X_3974_ _5618_/Q _4541_/S _5619_/Q VGND VGND VPWR VPWR _3978_/B sky130_fd_sc_hd__a21oi_1
X_2925_ _2871_/B _2925_/B _6018_/Q _2925_/D VGND VGND VPWR VPWR _2925_/X sky130_fd_sc_hd__and4b_1
X_5713_ _5723_/CLK _5713_/D fanout293/X VGND VGND VPWR VPWR _5713_/Q sky130_fd_sc_hd__dfrtp_1
XTAP_TAPCELL_ROW_33_588 VGND VPWR sky130_fd_sc_hd__tapvpwrvgnd_1
X_2856_ _2856_/A _2856_/B _2856_/C VGND VGND VPWR VPWR _2856_/X sky130_fd_sc_hd__or3_1
X_5644_ _5690_/CLK _5644_/D VGND VGND VPWR VPWR hold7/A sky130_fd_sc_hd__dfxtp_1
Xhold200 _6087_/Q VGND VGND VPWR VPWR hold200/X sky130_fd_sc_hd__dlygate4sd3_1
Xhold211 _5782_/Q VGND VGND VPWR VPWR hold211/X sky130_fd_sc_hd__dlygate4sd3_1
X_2787_ _2871_/B _2871_/C _2864_/A VGND VGND VPWR VPWR _2787_/X sky130_fd_sc_hd__and3b_1
X_5575_ _6050_/CLK _5575_/D fanout288/X VGND VGND VPWR VPWR _5575_/Q sky130_fd_sc_hd__dfrtp_2
Xhold233 _6002_/Q VGND VGND VPWR VPWR hold233/X sky130_fd_sc_hd__dlygate4sd3_1
Xhold244 _5823_/Q VGND VGND VPWR VPWR hold244/X sky130_fd_sc_hd__dlygate4sd3_1
XANTENNA_fanout202_A _6113_/Q VGND VGND VPWR VPWR sky130_fd_sc_hd__diode_2
XANTENNA__4750__A1 _4750_/A1 VGND VGND VPWR VPWR sky130_fd_sc_hd__diode_2
X_4526_ _4496_/A _4520_/X _4533_/B _4525_/X VGND VGND VPWR VPWR _4526_/X sky130_fd_sc_hd__o22a_1
Xhold222 _6116_/Q VGND VGND VPWR VPWR hold222/X sky130_fd_sc_hd__dlygate4sd3_1
Xhold266 _5820_/Q VGND VGND VPWR VPWR hold266/X sky130_fd_sc_hd__dlygate4sd3_1
Xhold277 _5890_/Q VGND VGND VPWR VPWR hold277/X sky130_fd_sc_hd__dlygate4sd3_1
Xhold255 _6052_/Q VGND VGND VPWR VPWR hold255/X sky130_fd_sc_hd__dlygate4sd3_1
X_4457_ _4496_/A _4456_/Y _4499_/A VGND VGND VPWR VPWR _4457_/X sky130_fd_sc_hd__a21o_1
Xhold299 _5788_/Q VGND VGND VPWR VPWR hold299/X sky130_fd_sc_hd__dlygate4sd3_1
Xhold288 _5892_/Q VGND VGND VPWR VPWR hold288/X sky130_fd_sc_hd__dlygate4sd3_1
X_3408_ _5612_/Q _3408_/B _3958_/B VGND VGND VPWR VPWR _3416_/S sky130_fd_sc_hd__and3b_4
X_4388_ _4408_/A _4452_/B VGND VGND VPWR VPWR _4390_/A sky130_fd_sc_hd__and2_1
X_6127_ _6161_/CLK _6127_/D fanout311/X VGND VGND VPWR VPWR _6127_/Q sky130_fd_sc_hd__dfrtp_1
XTAP_TAPCELL_ROW_5_247 VGND VPWR sky130_fd_sc_hd__tapvpwrvgnd_1
XANTENNA_fanout192_X _5397_/A VGND VGND VPWR VPWR sky130_fd_sc_hd__diode_2
X_3339_ _3336_/A _6025_/Q _3282_/C _3280_/C _3291_/Y VGND VGND VPWR VPWR _3354_/C
+ sky130_fd_sc_hd__a2111o_1
X_6058_ _6106_/CLK _6058_/D fanout283/X VGND VGND VPWR VPWR _6058_/Q sky130_fd_sc_hd__dfrtp_1
X_5009_ hold464/X _5025_/A2 _5008_/X VGND VGND VPWR VPWR _5950_/D sky130_fd_sc_hd__a21o_1
XFILLER_26_354 VGND VGND VPWR VPWR sky130_fd_sc_hd__fill_1
XFILLER_38_192 VGND VGND VPWR VPWR sky130_fd_sc_hd__decap_4
XTAP_TAPCELL_ROW_52_831 VGND VPWR sky130_fd_sc_hd__tapvpwrvgnd_1
XANTENNA__5156__S _5172_/S VGND VGND VPWR VPWR sky130_fd_sc_hd__diode_2
XANTENNA__3184__B _3426_/D VGND VGND VPWR VPWR sky130_fd_sc_hd__diode_2
XANTENNA__3752__X _3913_/B VGND VGND VPWR VPWR sky130_fd_sc_hd__diode_2
XFILLER_76_232 VGND VGND VPWR VPWR sky130_fd_sc_hd__fill_1
XANTENNA__3404__S _3407_/S VGND VGND VPWR VPWR sky130_fd_sc_hd__diode_2
XANTENNA__2809__A _6114_/Q VGND VGND VPWR VPWR sky130_fd_sc_hd__diode_2
XFILLER_39_94 VGND VGND VPWR VPWR sky130_fd_sc_hd__fill_1
XFILLER_45_641 VGND VGND VPWR VPWR sky130_fd_sc_hd__fill_1
XFILLER_44_195 VGND VGND VPWR VPWR sky130_fd_sc_hd__fill_1
XFILLER_60_699 VGND VGND VPWR VPWR sky130_fd_sc_hd__fill_1
XFILLER_20_508 VGND VGND VPWR VPWR sky130_fd_sc_hd__fill_2
XTAP_TAPCELL_ROW_80_1196 VGND VPWR sky130_fd_sc_hd__tapvpwrvgnd_1
XTAP_TAPCELL_ROW_80_1185 VGND VPWR sky130_fd_sc_hd__tapvpwrvgnd_1
XTAP_TAPCELL_ROW_80_1174 VGND VPWR sky130_fd_sc_hd__tapvpwrvgnd_1
XFILLER_13_582 VPWR VGND VPWR VGND sky130_ef_sc_hd__decap_12
XANTENNA__4980__B2 _4880_/X VGND VGND VPWR VPWR sky130_fd_sc_hd__diode_2
X_3690_ _4399_/A _6051_/Q VGND VGND VPWR VPWR _3714_/D sky130_fd_sc_hd__nor2_1
XTAP_TAPCELL_ROW_30_558 VGND VPWR sky130_fd_sc_hd__tapvpwrvgnd_1
XANTENNA__5066__S _5066_/S VGND VGND VPWR VPWR sky130_fd_sc_hd__diode_2
XFILLER_58_3 VGND VGND VPWR VPWR sky130_fd_sc_hd__fill_2
X_5360_ _5410_/C _5355_/X _6162_/Q VGND VGND VPWR VPWR _6162_/D sky130_fd_sc_hd__mux2_1
X_4311_ _5716_/Q _4265_/X _4310_/X _4252_/X VGND VGND VPWR VPWR _4311_/X sky130_fd_sc_hd__a22o_1
X_5291_ _6152_/Q _5343_/B VGND VGND VPWR VPWR _5301_/A sky130_fd_sc_hd__nand2_1
X_4242_ _5943_/Q _4748_/A2 _4747_/A2 _5910_/Q VGND VGND VPWR VPWR _4242_/X sky130_fd_sc_hd__a22o_1
XFILLER_4_280 VGND VGND VPWR VPWR sky130_fd_sc_hd__fill_2
X_4173_ _5903_/Q _5760_/Q _4241_/S VGND VGND VPWR VPWR _4173_/X sky130_fd_sc_hd__mux2_1
X_3124_ _2993_/A _6062_/Q _4978_/C _3123_/X _2989_/Y VGND VGND VPWR VPWR _3124_/X
+ sky130_fd_sc_hd__a41o_1
XTAP_TAPCELL_ROW_2_206 VGND VPWR sky130_fd_sc_hd__tapvpwrvgnd_1
X_3055_ _3050_/B _2765_/Y _2766_/Y _3053_/S hold99/A VGND VGND VPWR VPWR _5688_/D
+ sky130_fd_sc_hd__a221oi_1
Xclkbuf_leaf_47_clk clkload1/A VGND VGND VPWR VPWR _6161_/CLK sky130_fd_sc_hd__clkbuf_8
XFILLER_36_652 VGND VGND VPWR VPWR sky130_fd_sc_hd__fill_1
XTAP_TAPCELL_ROW_38_658 VGND VPWR sky130_fd_sc_hd__tapvpwrvgnd_1
XFILLER_70_419 VGND VGND VPWR VPWR sky130_fd_sc_hd__fill_1
XFILLER_63_493 VGND VGND VPWR VPWR sky130_fd_sc_hd__fill_1
XFILLER_50_110 VGND VGND VPWR VPWR sky130_fd_sc_hd__fill_1
XFILLER_23_335 VGND VGND VPWR VPWR sky130_fd_sc_hd__fill_1
XANTENNA__3223__A1 _5488_/Q VGND VGND VPWR VPWR sky130_fd_sc_hd__diode_2
X_3957_ hold319/X _3954_/B _3956_/X _3958_/B VGND VGND VPWR VPWR _5611_/D sky130_fd_sc_hd__a22o_1
X_2908_ _6130_/Q _2908_/B VGND VGND VPWR VPWR _2908_/X sky130_fd_sc_hd__and2_1
X_3888_ _4517_/A _4762_/C _3887_/X _3845_/B VGND VGND VPWR VPWR _3888_/X sky130_fd_sc_hd__a211o_1
X_5627_ _5963_/CLK input2/X VGND VGND VPWR VPWR hold10/A sky130_fd_sc_hd__dfxtp_2
X_2839_ _2837_/X _2838_/X _2908_/B VGND VGND VPWR VPWR _2839_/X sky130_fd_sc_hd__o21ba_1
X_5558_ _6120_/CLK _5558_/D VGND VGND VPWR VPWR hold80/A sky130_fd_sc_hd__dfxtp_1
XFILLER_2_228 VGND VGND VPWR VPWR sky130_fd_sc_hd__fill_1
X_4509_ _4522_/B _4509_/B VGND VGND VPWR VPWR _4509_/Y sky130_fd_sc_hd__nand2_1
X_5489_ _6085_/CLK _5489_/D fanout332/X VGND VGND VPWR VPWR _5489_/Q sky130_fd_sc_hd__dfrtp_4
XANTENNA__3224__S _3229_/S VGND VGND VPWR VPWR sky130_fd_sc_hd__diode_2
XFILLER_58_210 VGND VGND VPWR VPWR sky130_fd_sc_hd__fill_1
Xclkbuf_leaf_38_clk clkload1/A VGND VGND VPWR VPWR _5696_/CLK sky130_fd_sc_hd__clkbuf_8
XFILLER_14_335 VGND VGND VPWR VPWR sky130_fd_sc_hd__fill_2
XANTENNA__3765__A2 _3725_/C VGND VGND VPWR VPWR sky130_fd_sc_hd__diode_2
XANTENNA__4714__A1 _2934_/B VGND VGND VPWR VPWR sky130_fd_sc_hd__diode_2
XFILLER_37_449 VGND VGND VPWR VPWR sky130_fd_sc_hd__fill_1
XTAP_TAPCELL_ROW_69_1047 VGND VPWR sky130_fd_sc_hd__tapvpwrvgnd_1
Xclkbuf_leaf_29_clk clkload2/A VGND VGND VPWR VPWR _6092_/CLK sky130_fd_sc_hd__clkbuf_8
XANTENNA__4650__A0 _5470_/Q VGND VGND VPWR VPWR sky130_fd_sc_hd__diode_2
XTAP_TAPCELL_ROW_35_617 VGND VPWR sky130_fd_sc_hd__tapvpwrvgnd_1
XFILLER_45_482 VGND VGND VPWR VPWR sky130_fd_sc_hd__fill_1
X_4860_ _2934_/B hold256/X _4864_/S VGND VGND VPWR VPWR _5894_/D sky130_fd_sc_hd__mux2_1
X_3811_ _5571_/Q _5572_/Q _3811_/C VGND VGND VPWR VPWR _3834_/C sky130_fd_sc_hd__and3_1
X_4791_ _5491_/Q hold161/X _4805_/S VGND VGND VPWR VPWR _5828_/D sky130_fd_sc_hd__mux2_1
XFILLER_60_485 VGND VGND VPWR VPWR sky130_fd_sc_hd__decap_8
XTAP_TAPCELL_ROW_15_363 VGND VPWR sky130_fd_sc_hd__tapvpwrvgnd_1
XFILLER_32_187 VGND VGND VPWR VPWR sky130_fd_sc_hd__decap_8
X_3742_ _5900_/Q _4109_/C _4865_/A VGND VGND VPWR VPWR _4113_/B sky130_fd_sc_hd__and3_1
XFILLER_9_350 VPWR VGND VPWR VGND sky130_ef_sc_hd__decap_12
XFILLER_20_349 VGND VGND VPWR VPWR sky130_fd_sc_hd__decap_6
X_3673_ _6105_/Q _4491_/A _6108_/Q _4530_/A VGND VGND VPWR VPWR _3709_/D sky130_fd_sc_hd__a2bb2o_1
X_5412_ _5412_/A _5427_/B VGND VGND VPWR VPWR _5430_/A sky130_fd_sc_hd__and2_1
X_5343_ _6160_/Q _5343_/B VGND VGND VPWR VPWR _5343_/X sky130_fd_sc_hd__xor2_1
X_5274_ _5274_/A _5274_/B VGND VGND VPWR VPWR _5276_/A sky130_fd_sc_hd__nor2_1
X_4225_ _4224_/X _4220_/X _4234_/S VGND VGND VPWR VPWR _4225_/X sky130_fd_sc_hd__mux2_1
X_4156_ _4155_/B _4155_/C _4155_/A VGND VGND VPWR VPWR _4157_/C sky130_fd_sc_hd__o21ai_1
XFILLER_55_202 VGND VGND VPWR VPWR sky130_fd_sc_hd__decap_3
X_3107_ _5684_/Q _3104_/B _3106_/Y VGND VGND VPWR VPWR _3107_/X sky130_fd_sc_hd__o21a_1
XFILLER_46_29 VGND VGND VPWR VPWR sky130_fd_sc_hd__fill_1
X_4087_ _5585_/Q hold69/X _4091_/S VGND VGND VPWR VPWR _5694_/D sky130_fd_sc_hd__mux2_1
XFILLER_70_205 VGND VGND VPWR VPWR sky130_fd_sc_hd__decap_8
X_3038_ _5951_/Q _3153_/B _3037_/X VGND VGND VPWR VPWR _3038_/X sky130_fd_sc_hd__o21a_1
XFILLER_36_471 VGND VGND VPWR VPWR sky130_fd_sc_hd__decap_4
X_4989_ _5940_/Q _5041_/A2 _4988_/X VGND VGND VPWR VPWR _5940_/D sky130_fd_sc_hd__a21o_1
XFILLER_51_496 VGND VGND VPWR VPWR sky130_fd_sc_hd__fill_2
XANTENNA__3219__S _3219_/S VGND VGND VPWR VPWR sky130_fd_sc_hd__diode_2
Xfanout340 fanout341/X VGND VGND VPWR VPWR fanout340/X sky130_fd_sc_hd__clkbuf_2
XANTENNA__5121__A1 _4517_/A VGND VGND VPWR VPWR sky130_fd_sc_hd__diode_2
Xfanout351 fanout352/X VGND VGND VPWR VPWR fanout351/X sky130_fd_sc_hd__buf_2
XANTENNA__4880__A0 _5793_/Q VGND VGND VPWR VPWR sky130_fd_sc_hd__diode_2
XANTENNA__3683__A1 _4452_/A VGND VGND VPWR VPWR sky130_fd_sc_hd__diode_2
XFILLER_19_449 VGND VGND VPWR VPWR sky130_fd_sc_hd__decap_8
XFILLER_74_599 VGND VGND VPWR VPWR sky130_fd_sc_hd__fill_1
XFILLER_34_419 VGND VGND VPWR VPWR sky130_fd_sc_hd__fill_1
XTAP_TAPCELL_ROW_60_929 VGND VPWR sky130_fd_sc_hd__tapvpwrvgnd_1
XFILLER_15_677 VGND VGND VPWR VPWR sky130_fd_sc_hd__fill_1
XANTENNA__3199__A0 _2934_/B VGND VGND VPWR VPWR sky130_fd_sc_hd__diode_2
XFILLER_52_50 VPWR VGND VPWR VGND sky130_ef_sc_hd__decap_12
XFILLER_14_176 VGND VGND VPWR VPWR sky130_fd_sc_hd__decap_3
XANTENNA__3738__A2 _5719_/Q VGND VGND VPWR VPWR sky130_fd_sc_hd__diode_2
XTAP_TAPCELL_ROW_12_333 VGND VPWR sky130_fd_sc_hd__tapvpwrvgnd_1
XFILLER_10_360 VGND VGND VPWR VPWR sky130_fd_sc_hd__decap_4
XTAP_TAPCELL_ROW_40_675 VGND VPWR sky130_fd_sc_hd__tapvpwrvgnd_1
XTAP_TAPCELL_ROW_40_686 VGND VPWR sky130_fd_sc_hd__tapvpwrvgnd_1
XANTENNA__4699__B1 _4747_/B1 VGND VGND VPWR VPWR sky130_fd_sc_hd__diode_2
XANTENNA__3371__B1 _5109_/S VGND VGND VPWR VPWR sky130_fd_sc_hd__diode_2
XANTENNA__5112__A1 _4404_/A VGND VGND VPWR VPWR sky130_fd_sc_hd__diode_2
XFILLER_2_581 VGND VGND VPWR VPWR sky130_fd_sc_hd__decap_6
X_4010_ hold392/X _3050_/B hold9/A _4009_/Y _4008_/X VGND VGND VPWR VPWR _5647_/D
+ sky130_fd_sc_hd__a221o_1
XFILLER_77_393 VGND VGND VPWR VPWR sky130_fd_sc_hd__decap_8
XTAP_TAPCELL_ROW_48_786 VGND VPWR sky130_fd_sc_hd__tapvpwrvgnd_1
XTAP_TAPCELL_ROW_48_775 VGND VPWR sky130_fd_sc_hd__tapvpwrvgnd_1
X_5961_ _6110_/CLK _5961_/D fanout301/X VGND VGND VPWR VPWR _5961_/Q sky130_fd_sc_hd__dfrtp_1
X_4912_ hold439/X _4951_/A2 _4911_/X VGND VGND VPWR VPWR _5913_/D sky130_fd_sc_hd__a21o_1
X_5892_ _6088_/CLK _5892_/D fanout340/X VGND VGND VPWR VPWR _5892_/Q sky130_fd_sc_hd__dfrtp_1
XANTENNA__5179__A1 _4447_/B VGND VGND VPWR VPWR sky130_fd_sc_hd__diode_2
XFILLER_33_463 VGND VGND VPWR VPWR sky130_fd_sc_hd__fill_2
X_4843_ _5489_/Q hold281/X _4863_/S VGND VGND VPWR VPWR _5877_/D sky130_fd_sc_hd__mux2_1
X_4774_ hold127/X _3877_/X _4774_/S VGND VGND VPWR VPWR _5812_/D sky130_fd_sc_hd__mux2_1
X_3725_ _3725_/A _3725_/B _3725_/C VGND VGND VPWR VPWR _3725_/Y sky130_fd_sc_hd__nor3_1
Xclkbuf_leaf_9_clk clkbuf_leaf_9_clk/A VGND VGND VPWR VPWR _5811_/CLK sky130_fd_sc_hd__clkbuf_8
X_3656_ _3656_/A _6041_/Q VGND VGND VPWR VPWR _3720_/C sky130_fd_sc_hd__and2_1
X_3587_ _6102_/Q _4452_/A VGND VGND VPWR VPWR _3709_/B sky130_fd_sc_hd__nor2_1
X_5326_ _5326_/A _5326_/B VGND VGND VPWR VPWR _5327_/B sky130_fd_sc_hd__or2_1
X_5257_ _5257_/A _5257_/B VGND VGND VPWR VPWR _5258_/B sky130_fd_sc_hd__nor2_1
XANTENNA__5103__A1 _5397_/A VGND VGND VPWR VPWR sky130_fd_sc_hd__diode_2
X_4208_ _4207_/X _4205_/X _4235_/S VGND VGND VPWR VPWR _4209_/B sky130_fd_sc_hd__mux2_1
XFILLER_57_28 VGND VGND VPWR VPWR sky130_fd_sc_hd__fill_1
XFILLER_68_371 VGND VGND VPWR VPWR sky130_fd_sc_hd__decap_8
XFILLER_56_500 VGND VGND VPWR VPWR sky130_fd_sc_hd__fill_1
XANTENNA__4862__A0 _4967_/A0 VGND VGND VPWR VPWR sky130_fd_sc_hd__diode_2
X_5188_ _5353_/B _5188_/B VGND VGND VPWR VPWR _6109_/D sky130_fd_sc_hd__nor2_1
X_4139_ _4164_/B _4139_/B VGND VGND VPWR VPWR _4152_/A sky130_fd_sc_hd__nand2_1
XANTENNA__4394__A _4408_/A VGND VGND VPWR VPWR sky130_fd_sc_hd__diode_2
XFILLER_16_419 VGND VGND VPWR VPWR sky130_fd_sc_hd__fill_1
XFILLER_43_249 VGND VGND VPWR VPWR sky130_fd_sc_hd__fill_1
XFILLER_11_113 VGND VGND VPWR VPWR sky130_fd_sc_hd__fill_2
XFILLER_12_669 VPWR VGND VPWR VGND sky130_ef_sc_hd__decap_12
XANTENNA__5726__Q _5726_/Q VGND VGND VPWR VPWR sky130_fd_sc_hd__diode_2
XFILLER_22_97 VGND VGND VPWR VPWR sky130_fd_sc_hd__fill_1
XANTENNA__5164__S _5172_/S VGND VGND VPWR VPWR sky130_fd_sc_hd__diode_2
XFILLER_3_334 VGND VGND VPWR VPWR sky130_fd_sc_hd__fill_2
XFILLER_78_102 VGND VGND VPWR VPWR sky130_fd_sc_hd__fill_2
XANTENNA__4853__A0 _5471_/Q VGND VGND VPWR VPWR sky130_fd_sc_hd__diode_2
Xfanout181 _2787_/X VGND VGND VPWR VPWR _2917_/A2 sky130_fd_sc_hd__clkbuf_4
Xfanout170 _2964_/B VGND VGND VPWR VPWR _3396_/A sky130_fd_sc_hd__clkbuf_4
Xfanout192 _6168_/Q VGND VGND VPWR VPWR _5397_/A sky130_fd_sc_hd__buf_2
XFILLER_59_393 VGND VGND VPWR VPWR sky130_fd_sc_hd__fill_1
XANTENNA__2817__A _5754_/Q VGND VGND VPWR VPWR sky130_fd_sc_hd__diode_2
XTAP_TAPCELL_ROW_66_1006 VGND VPWR sky130_fd_sc_hd__tapvpwrvgnd_1
XFILLER_34_216 VGND VGND VPWR VPWR sky130_fd_sc_hd__fill_2
XFILLER_34_249 VGND VGND VPWR VPWR sky130_fd_sc_hd__decap_3
XTAP_TAPCELL_ROW_45_745 VGND VPWR sky130_fd_sc_hd__tapvpwrvgnd_1
XFILLER_30_411 VGND VGND VPWR VPWR sky130_fd_sc_hd__fill_2
XANTENNA__4243__S _4243_/S VGND VGND VPWR VPWR sky130_fd_sc_hd__diode_2
XTAP_TAPCELL_ROW_25_491 VGND VPWR sky130_fd_sc_hd__tapvpwrvgnd_1
XFILLER_30_433 VGND VGND VPWR VPWR sky130_fd_sc_hd__decap_4
XFILLER_30_477 VPWR VGND VPWR VGND sky130_ef_sc_hd__decap_12
XANTENNA__5030__B1 _5038_/B1 VGND VGND VPWR VPWR sky130_fd_sc_hd__diode_2
X_3510_ _6119_/D _3517_/B _3492_/X _6140_/D VGND VGND VPWR VPWR _3545_/B sky130_fd_sc_hd__a22oi_2
XTAP_TAPCELL_ROW_77_1146 VGND VPWR sky130_fd_sc_hd__tapvpwrvgnd_1
X_4490_ _4357_/X _4489_/X _4475_/Y VGND VGND VPWR VPWR _5746_/D sky130_fd_sc_hd__o21ai_1
XANTENNA__5074__S _5098_/S VGND VGND VPWR VPWR sky130_fd_sc_hd__diode_2
XFILLER_6_183 VGND VGND VPWR VPWR sky130_fd_sc_hd__fill_1
X_3441_ hold86/X _5588_/Q _3442_/S VGND VGND VPWR VPWR _5555_/D sky130_fd_sc_hd__mux2_1
X_6160_ _6160_/CLK _6160_/D fanout310/X VGND VGND VPWR VPWR _6160_/Q sky130_fd_sc_hd__dfrtp_1
XFILLER_40_3 VGND VGND VPWR VPWR sky130_fd_sc_hd__decap_4
X_3372_ _5979_/Q _6023_/Q _3394_/S VGND VGND VPWR VPWR _3372_/X sky130_fd_sc_hd__mux2_1
XFILLER_69_113 VPWR VGND VPWR VGND sky130_ef_sc_hd__decap_12
X_5111_ _6034_/Q _3905_/A _5127_/B VGND VGND VPWR VPWR _6034_/D sky130_fd_sc_hd__mux2_1
X_6091_ _6091_/CLK _6091_/D fanout347/X VGND VGND VPWR VPWR _6091_/Q sky130_fd_sc_hd__dfrtp_1
XANTENNA__4844__A0 _5490_/Q VGND VGND VPWR VPWR sky130_fd_sc_hd__diode_2
XFILLER_69_179 VGND VGND VPWR VPWR sky130_fd_sc_hd__decap_4
X_5042_ _4749_/X _4979_/A _4979_/B _4973_/X VGND VGND VPWR VPWR _5042_/X sky130_fd_sc_hd__a22o_1
XFILLER_53_503 VGND VGND VPWR VPWR sky130_fd_sc_hd__fill_1
X_5944_ _6021_/CLK _5944_/D fanout330/X VGND VGND VPWR VPWR _5944_/Q sky130_fd_sc_hd__dfrtp_1
XFILLER_40_208 VGND VGND VPWR VPWR sky130_fd_sc_hd__decap_8
X_5875_ _6092_/CLK _5875_/D fanout342/X VGND VGND VPWR VPWR _5875_/Q sky130_fd_sc_hd__dfrtp_1
X_4826_ _4826_/A _5122_/S VGND VGND VPWR VPWR _5861_/D sky130_fd_sc_hd__or2_1
XANTENNA_fanout232_A _4522_/C VGND VGND VPWR VPWR sky130_fd_sc_hd__diode_2
XFILLER_21_488 VGND VGND VPWR VPWR sky130_fd_sc_hd__decap_3
XANTENNA__3277__B _5397_/A VGND VGND VPWR VPWR sky130_fd_sc_hd__diode_2
X_4757_ _5796_/Q _4761_/A2 _4561_/B _3548_/Y VGND VGND VPWR VPWR _5796_/D sky130_fd_sc_hd__a22o_1
XANTENNA_fanout118_X _5098_/S VGND VGND VPWR VPWR sky130_fd_sc_hd__diode_2
X_4688_ _4684_/X _4686_/X _4687_/X _4688_/B2 _4720_/C1 VGND VGND VPWR VPWR _4688_/X
+ sky130_fd_sc_hd__a221o_1
X_3708_ _4873_/A _4873_/B _3708_/C _3708_/D VGND VGND VPWR VPWR _3710_/C sky130_fd_sc_hd__or4_1
X_3639_ _3639_/A _6042_/Q VGND VGND VPWR VPWR _3697_/A sky130_fd_sc_hd__xor2_1
XANTENNA__4389__A _4408_/A VGND VGND VPWR VPWR sky130_fd_sc_hd__diode_2
X_5309_ _6155_/Q _5343_/B VGND VGND VPWR VPWR _5318_/A sky130_fd_sc_hd__nand2_1
XFILLER_29_511 VGND VGND VPWR VPWR sky130_fd_sc_hd__fill_1
XFILLER_17_706 VGND VGND VPWR VPWR sky130_fd_sc_hd__decap_6
XANTENNA__2861__A2 _2783_/B VGND VGND VPWR VPWR sky130_fd_sc_hd__diode_2
XFILLER_16_216 VGND VGND VPWR VPWR sky130_fd_sc_hd__fill_1
XFILLER_17_75 VGND VGND VPWR VPWR sky130_fd_sc_hd__fill_2
XTAP_TAPCELL_ROW_42_704 VGND VPWR sky130_fd_sc_hd__tapvpwrvgnd_1
XANTENNA__5159__S _5167_/S VGND VGND VPWR VPWR sky130_fd_sc_hd__diode_2
XFILLER_12_455 VGND VGND VPWR VPWR sky130_fd_sc_hd__fill_2
XANTENNA__5012__B1 _5026_/B1 VGND VGND VPWR VPWR sky130_fd_sc_hd__diode_2
XTAP_TAPCELL_ROW_22_450 VGND VPWR sky130_fd_sc_hd__tapvpwrvgnd_1
XTAP_TAPCELL_ROW_22_461 VGND VPWR sky130_fd_sc_hd__tapvpwrvgnd_1
XANTENNA__3169__A3 _4967_/A0 VGND VGND VPWR VPWR sky130_fd_sc_hd__diode_2
XANTENNA__3407__S _3407_/S VGND VGND VPWR VPWR sky130_fd_sc_hd__diode_2
Xtt_um_bfcpu_365 VGND VGND VPWR VPWR tt_um_bfcpu_365/HI uo_out[3] sky130_fd_sc_hd__conb_1
Xtt_um_bfcpu_354 VGND VGND VPWR VPWR tt_um_bfcpu_354/HI uio_oe[1] sky130_fd_sc_hd__conb_1
XTAP_TAPCELL_ROW_72_1076 VGND VPWR sky130_fd_sc_hd__tapvpwrvgnd_1
XANTENNA__3629__A1 _2744_/A VGND VGND VPWR VPWR sky130_fd_sc_hd__diode_2
Xhold4 hold4/A VGND VGND VPWR VPWR hold4/X sky130_fd_sc_hd__dlygate4sd3_1
XANTENNA__2852__A2 _2886_/B VGND VGND VPWR VPWR sky130_fd_sc_hd__diode_2
XFILLER_35_525 VGND VGND VPWR VPWR sky130_fd_sc_hd__decap_6
X_3990_ _5659_/Q _5643_/Q _5623_/Q _5624_/Q VGND VGND VPWR VPWR _3992_/B sky130_fd_sc_hd__a31o_1
XANTENNA__4762__A _4873_/A VGND VGND VPWR VPWR sky130_fd_sc_hd__diode_2
X_2941_ _2938_/X _2939_/X _2940_/X _2941_/B1 _5520_/Q VGND VGND VPWR VPWR _2941_/X
+ sky130_fd_sc_hd__a32o_1
XANTENNA__5069__S _5097_/S VGND VGND VPWR VPWR sky130_fd_sc_hd__diode_2
X_5660_ _6113_/CLK _5660_/D VGND VGND VPWR VPWR _5660_/Q sky130_fd_sc_hd__dfxtp_1
X_4611_ _5950_/Q _4683_/A2 _4667_/B1 _4610_/X VGND VGND VPWR VPWR _4611_/X sky130_fd_sc_hd__a22o_1
X_2872_ _6072_/Q _2928_/A2 _2927_/B1 _6084_/Q _2871_/X VGND VGND VPWR VPWR _2872_/X
+ sky130_fd_sc_hd__a221o_1
XANTENNA__3463__C_N _6130_/D VGND VGND VPWR VPWR sky130_fd_sc_hd__diode_2
X_5591_ _5697_/CLK _5591_/D fanout319/X VGND VGND VPWR VPWR _5591_/Q sky130_fd_sc_hd__dfrtp_1
X_4542_ _4542_/A _4542_/B VGND VGND VPWR VPWR _5752_/D sky130_fd_sc_hd__and2_1
XANTENNA__4701__S _4735_/S VGND VGND VPWR VPWR sky130_fd_sc_hd__diode_2
Xmax_cap134 _4254_/Y VGND VGND VPWR VPWR _4273_/B sky130_fd_sc_hd__buf_1
Xhold404 _5916_/Q VGND VGND VPWR VPWR hold404/X sky130_fd_sc_hd__dlygate4sd3_1
Xhold426 _6148_/Q VGND VGND VPWR VPWR hold426/X sky130_fd_sc_hd__dlygate4sd3_1
Xhold415 _6159_/Q VGND VGND VPWR VPWR hold415/X sky130_fd_sc_hd__dlygate4sd3_1
X_4473_ _4436_/S _4470_/X _4472_/Y _4462_/A VGND VGND VPWR VPWR _4473_/X sky130_fd_sc_hd__o211a_1
Xhold459 _5922_/Q VGND VGND VPWR VPWR hold459/X sky130_fd_sc_hd__dlygate4sd3_1
Xhold448 _5942_/Q VGND VGND VPWR VPWR hold448/X sky130_fd_sc_hd__dlygate4sd3_1
Xhold437 _5939_/Q VGND VGND VPWR VPWR hold437/X sky130_fd_sc_hd__dlygate4sd3_1
X_3424_ _5641_/Q hold79/X _3961_/A VGND VGND VPWR VPWR _5539_/D sky130_fd_sc_hd__mux2_1
X_6143_ _6144_/CLK _6143_/D fanout331/X VGND VGND VPWR VPWR _6143_/Q sky130_fd_sc_hd__dfrtp_1
X_3355_ _3355_/A _3355_/B _3355_/C _3355_/D VGND VGND VPWR VPWR _3358_/A sky130_fd_sc_hd__or4_1
X_6074_ _6094_/CLK _6074_/D fanout349/X VGND VGND VPWR VPWR _6074_/Q sky130_fd_sc_hd__dfrtp_1
X_3286_ _5412_/A _3272_/B _3357_/C _3357_/D VGND VGND VPWR VPWR _3295_/C sky130_fd_sc_hd__a211o_1
X_5025_ hold414/X _5025_/A2 _5024_/X VGND VGND VPWR VPWR _5958_/D sky130_fd_sc_hd__a21o_1
XFILLER_80_130 VGND VGND VPWR VPWR sky130_fd_sc_hd__decap_3
XTAP_TAPCELL_ROW_0_167 VGND VPWR sky130_fd_sc_hd__tapvpwrvgnd_1
XTAP_TAPCELL_ROW_0_178 VGND VPWR sky130_fd_sc_hd__tapvpwrvgnd_1
X_5927_ _5966_/CLK _5927_/D fanout307/X VGND VGND VPWR VPWR _5927_/Q sky130_fd_sc_hd__dfrtp_1
XANTENNA__3559__Y _3559_/Y VGND VGND VPWR VPWR sky130_fd_sc_hd__diode_2
XFILLER_21_241 VGND VGND VPWR VPWR sky130_fd_sc_hd__fill_2
X_5858_ _6026_/CLK _5858_/D fanout280/X VGND VGND VPWR VPWR _5858_/Q sky130_fd_sc_hd__dfrtp_1
XANTENNA_fanout235_X _3647_/A VGND VGND VPWR VPWR sky130_fd_sc_hd__diode_2
X_4809_ _4970_/A0 hold278/X _4809_/S VGND VGND VPWR VPWR _5846_/D sky130_fd_sc_hd__mux2_1
X_5789_ _5942_/CLK _5789_/D fanout297/X VGND VGND VPWR VPWR _5789_/Q sky130_fd_sc_hd__dfrtp_1
XPHY_EDGE_ROW_17_Right_17 VGND VGND VPWR VPWR sky130_fd_sc_hd__decap_3
XFILLER_5_429 VPWR VGND VPWR VGND sky130_ef_sc_hd__decap_12
XFILLER_79_15 VGND VGND VPWR VPWR sky130_fd_sc_hd__fill_2
XANTENNA__3227__S _3229_/S VGND VGND VPWR VPWR sky130_fd_sc_hd__diode_2
XTAP_TAPCELL_ROW_8_278 VGND VPWR sky130_fd_sc_hd__tapvpwrvgnd_1
XFILLER_1_668 VGND VGND VPWR VPWR sky130_fd_sc_hd__decap_4
XFILLER_76_414 VGND VGND VPWR VPWR sky130_fd_sc_hd__fill_2
XANTENNA__4808__A0 _4967_/A0 VGND VGND VPWR VPWR sky130_fd_sc_hd__diode_2
XFILLER_0_167 VGND VGND VPWR VPWR sky130_fd_sc_hd__fill_1
XPHY_EDGE_ROW_26_Right_26 VGND VGND VPWR VPWR sky130_fd_sc_hd__decap_3
XFILLER_76_436 VGND VGND VPWR VPWR sky130_fd_sc_hd__fill_1
XFILLER_17_536 VPWR VGND VPWR VGND sky130_ef_sc_hd__decap_12
XFILLER_44_300 VGND VGND VPWR VPWR sky130_fd_sc_hd__decap_8
XFILLER_71_141 VPWR VGND VPWR VGND sky130_ef_sc_hd__decap_12
XFILLER_56_193 VGND VGND VPWR VPWR sky130_fd_sc_hd__decap_3
XTAP_TAPCELL_ROW_55_862 VGND VPWR sky130_fd_sc_hd__tapvpwrvgnd_1
XTAP_TAPCELL_ROW_27_520 VGND VPWR sky130_fd_sc_hd__tapvpwrvgnd_1
XTAP_TAPCELL_ROW_55_873 VGND VPWR sky130_fd_sc_hd__tapvpwrvgnd_1
XPHY_EDGE_ROW_35_Right_35 VGND VGND VPWR VPWR sky130_fd_sc_hd__decap_3
XANTENNA__4744__C1 _3877_/S VGND VGND VPWR VPWR sky130_fd_sc_hd__diode_2
XTAP_TAPCELL_ROW_74_1105 VGND VPWR sky130_fd_sc_hd__tapvpwrvgnd_1
XPHY_EDGE_ROW_44_Right_44 VGND VGND VPWR VPWR sky130_fd_sc_hd__decap_3
X_3140_ _2989_/Y _3127_/Y _3135_/Y _3139_/X _3138_/B VGND VGND VPWR VPWR _3141_/B
+ sky130_fd_sc_hd__a311o_1
X_3071_ _5606_/Q _5655_/Q VGND VGND VPWR VPWR _3071_/Y sky130_fd_sc_hd__nand2_1
X_5712_ _5723_/CLK _5712_/D fanout293/X VGND VGND VPWR VPWR _5712_/Q sky130_fd_sc_hd__dfrtp_1
XPHY_EDGE_ROW_53_Right_53 VGND VGND VPWR VPWR sky130_fd_sc_hd__decap_3
XFILLER_50_347 VGND VGND VPWR VPWR sky130_fd_sc_hd__fill_1
X_3973_ _5618_/Q _4541_/S _3972_/Y VGND VGND VPWR VPWR _5618_/D sky130_fd_sc_hd__o21a_1
X_2924_ _2921_/X _2922_/X _2923_/X _2803_/Y VGND VGND VPWR VPWR _2930_/C sky130_fd_sc_hd__o31a_1
XFILLER_31_561 VGND VGND VPWR VPWR sky130_fd_sc_hd__fill_1
X_2855_ _5829_/Q _2910_/B _2928_/A2 _5825_/Q VGND VGND VPWR VPWR _2856_/C sky130_fd_sc_hd__a22o_1
X_5643_ _5690_/CLK _5643_/D VGND VGND VPWR VPWR _5643_/Q sky130_fd_sc_hd__dfxtp_1
XTAP_TAPCELL_ROW_33_589 VGND VPWR sky130_fd_sc_hd__tapvpwrvgnd_1
X_5574_ _5811_/CLK _5574_/D fanout288/X VGND VGND VPWR VPWR _5574_/Q sky130_fd_sc_hd__dfrtp_2
Xhold201 _6070_/Q VGND VGND VPWR VPWR hold201/X sky130_fd_sc_hd__dlygate4sd3_1
X_2786_ _2925_/D _2920_/B _2871_/C VGND VGND VPWR VPWR _2786_/X sky130_fd_sc_hd__and3b_2
X_4525_ _4522_/C _4521_/B _3479_/X VGND VGND VPWR VPWR _4525_/X sky130_fd_sc_hd__a21o_1
Xhold234 _6086_/Q VGND VGND VPWR VPWR hold234/X sky130_fd_sc_hd__dlygate4sd3_1
Xhold212 _6012_/Q VGND VGND VPWR VPWR hold212/X sky130_fd_sc_hd__dlygate4sd3_1
Xhold223 _5869_/Q VGND VGND VPWR VPWR hold223/X sky130_fd_sc_hd__dlygate4sd3_1
Xhold245 _6021_/Q VGND VGND VPWR VPWR hold245/X sky130_fd_sc_hd__dlygate4sd3_1
Xhold278 _5846_/Q VGND VGND VPWR VPWR hold278/X sky130_fd_sc_hd__dlygate4sd3_1
Xhold267 _5780_/Q VGND VGND VPWR VPWR hold267/X sky130_fd_sc_hd__dlygate4sd3_1
XPHY_EDGE_ROW_62_Right_62 VGND VGND VPWR VPWR sky130_fd_sc_hd__decap_3
Xhold256 _5894_/Q VGND VGND VPWR VPWR hold256/X sky130_fd_sc_hd__dlygate4sd3_1
X_4456_ _4467_/A _4467_/C VGND VGND VPWR VPWR _4456_/Y sky130_fd_sc_hd__xnor2_1
Xhold289 _6006_/Q VGND VGND VPWR VPWR hold289/X sky130_fd_sc_hd__dlygate4sd3_1
X_3407_ _4973_/A0 _5524_/Q _3407_/S VGND VGND VPWR VPWR _5524_/D sky130_fd_sc_hd__mux2_1
X_4387_ _4357_/X _4386_/X _4373_/Y VGND VGND VPWR VPWR _5738_/D sky130_fd_sc_hd__o21ai_1
XTAP_TAPCELL_ROW_5_237 VGND VPWR sky130_fd_sc_hd__tapvpwrvgnd_1
X_6126_ _6161_/CLK _6126_/D fanout311/X VGND VGND VPWR VPWR _6126_/Q sky130_fd_sc_hd__dfrtp_2
X_3338_ _3355_/B _3356_/C _3356_/D _3338_/D VGND VGND VPWR VPWR _3341_/B sky130_fd_sc_hd__or4_1
XTAP_TAPCELL_ROW_5_248 VGND VPWR sky130_fd_sc_hd__tapvpwrvgnd_1
XANTENNA_fanout185_X _2895_/C VGND VGND VPWR VPWR sky130_fd_sc_hd__diode_2
X_6057_ _6061_/CLK _6057_/D fanout283/X VGND VGND VPWR VPWR _6057_/Q sky130_fd_sc_hd__dfrtp_1
X_3269_ _5362_/B _3353_/B VGND VGND VPWR VPWR _4551_/B sky130_fd_sc_hd__nor2_2
X_5008_ _4613_/X _5024_/A2 _5024_/B1 _4922_/X VGND VGND VPWR VPWR _5008_/X sky130_fd_sc_hd__a22o_1
XANTENNA_fanout352_X fanout352/X VGND VGND VPWR VPWR sky130_fd_sc_hd__diode_2
XPHY_EDGE_ROW_71_Right_71 VGND VGND VPWR VPWR sky130_fd_sc_hd__decap_3
XTAP_TAPCELL_ROW_52_832 VGND VPWR sky130_fd_sc_hd__tapvpwrvgnd_1
XFILLER_14_76 VGND VGND VPWR VPWR sky130_fd_sc_hd__fill_1
XANTENNA__4726__C1 _4750_/C1 VGND VGND VPWR VPWR sky130_fd_sc_hd__diode_2
XANTENNA_clkbuf_leaf_10_clk_A clkbuf_leaf_9_clk/A VGND VGND VPWR VPWR sky130_fd_sc_hd__diode_2
XPHY_EDGE_ROW_80_Right_80 VGND VGND VPWR VPWR sky130_fd_sc_hd__decap_3
XANTENNA_fanout98_X _5167_/S VGND VGND VPWR VPWR sky130_fd_sc_hd__diode_2
XFILLER_77_712 VGND VGND VPWR VPWR sky130_fd_sc_hd__fill_1
XANTENNA__5172__S _5172_/S VGND VGND VPWR VPWR sky130_fd_sc_hd__diode_2
XANTENNA_clkbuf_leaf_25_clk_A clkload2/A VGND VGND VPWR VPWR sky130_fd_sc_hd__diode_2
XFILLER_49_447 VGND VGND VPWR VPWR sky130_fd_sc_hd__fill_1
XFILLER_76_277 VGND VGND VPWR VPWR sky130_fd_sc_hd__fill_1
XFILLER_49_469 VPWR VGND VPWR VGND sky130_ef_sc_hd__decap_12
XANTENNA__2807__A2 _2783_/B VGND VGND VPWR VPWR sky130_fd_sc_hd__diode_2
XFILLER_29_171 VGND VGND VPWR VPWR sky130_fd_sc_hd__decap_3
XFILLER_55_94 VPWR VGND VPWR VGND sky130_ef_sc_hd__decap_12
XANTENNA__5201__A _5427_/A VGND VGND VPWR VPWR sky130_fd_sc_hd__diode_2
XTAP_TAPCELL_ROW_80_1186 VGND VPWR sky130_fd_sc_hd__tapvpwrvgnd_1
XTAP_TAPCELL_ROW_80_1175 VGND VPWR sky130_fd_sc_hd__tapvpwrvgnd_1
XFILLER_13_594 VGND VGND VPWR VPWR sky130_fd_sc_hd__decap_4
XTAP_TAPCELL_ROW_80_1197 VGND VPWR sky130_fd_sc_hd__tapvpwrvgnd_1
XTAP_TAPCELL_ROW_30_559 VGND VPWR sky130_fd_sc_hd__tapvpwrvgnd_1
XANTENNA__4732__A2 _4740_/A2 VGND VGND VPWR VPWR sky130_fd_sc_hd__diode_2
X_4310_ _5709_/Q _4309_/X _4310_/S VGND VGND VPWR VPWR _4310_/X sky130_fd_sc_hd__mux2_1
X_5290_ hold403/X _5252_/X _5289_/Y fanout9/X VGND VGND VPWR VPWR _6151_/D sky130_fd_sc_hd__a22o_1
X_4241_ _5943_/Q _5767_/Q _4241_/S VGND VGND VPWR VPWR _4241_/X sky130_fd_sc_hd__mux2_1
XANTENNA__5082__S _5098_/S VGND VGND VPWR VPWR sky130_fd_sc_hd__diode_2
XFILLER_68_712 VGND VGND VPWR VPWR sky130_fd_sc_hd__fill_1
X_4172_ _5769_/Q _4169_/X _4171_/X _3192_/B VGND VGND VPWR VPWR _4181_/A sky130_fd_sc_hd__o211a_1
X_3123_ _5518_/Q _5488_/Q _5468_/Q _2843_/B _3150_/B _3150_/C VGND VGND VPWR VPWR
+ _3123_/X sky130_fd_sc_hd__mux4_1
XTAP_TAPCELL_ROW_2_207 VGND VPWR sky130_fd_sc_hd__tapvpwrvgnd_1
X_3054_ _3054_/A _5688_/Q hold98/X VGND VGND VPWR VPWR hold99/A sky130_fd_sc_hd__nor3_1
XTAP_TAPCELL_ROW_38_659 VGND VPWR sky130_fd_sc_hd__tapvpwrvgnd_1
XFILLER_35_141 VPWR VGND VPWR VGND sky130_ef_sc_hd__decap_12
XANTENNA_fanout145_A _4876_/Y VGND VGND VPWR VPWR sky130_fd_sc_hd__diode_2
X_3956_ _3208_/A _3208_/C _3956_/S VGND VGND VPWR VPWR _3956_/X sky130_fd_sc_hd__mux2_1
X_2907_ _5519_/Q _2831_/Y _2905_/X _2906_/X _2837_/X VGND VGND VPWR VPWR _2907_/X
+ sky130_fd_sc_hd__a221o_1
X_5626_ _5645_/CLK _5626_/D fanout315/X VGND VGND VPWR VPWR _5626_/Q sky130_fd_sc_hd__dfstp_1
X_3887_ _3887_/A _5859_/Q VGND VGND VPWR VPWR _3887_/X sky130_fd_sc_hd__and2_1
X_2838_ _5517_/Q _2941_/B1 _2835_/X _2829_/X VGND VGND VPWR VPWR _2838_/X sky130_fd_sc_hd__a22o_1
XANTENNA__4723__A2 _5123_/B VGND VGND VPWR VPWR sky130_fd_sc_hd__diode_2
X_5557_ _5696_/CLK _5557_/D VGND VGND VPWR VPWR hold94/A sky130_fd_sc_hd__dfxtp_1
X_5488_ _6142_/CLK _5488_/D fanout329/X VGND VGND VPWR VPWR _5488_/Q sky130_fd_sc_hd__dfrtp_4
XANTENNA_fanout100_X _5170_/S VGND VGND VPWR VPWR sky130_fd_sc_hd__diode_2
X_4508_ _4522_/B _4509_/B VGND VGND VPWR VPWR _4521_/B sky130_fd_sc_hd__or2_1
X_4439_ _4444_/B _4439_/B VGND VGND VPWR VPWR _4440_/B sky130_fd_sc_hd__nor2_1
XFILLER_59_712 VGND VGND VPWR VPWR sky130_fd_sc_hd__fill_1
X_6109_ clkload8/A _6109_/D fanout285/X VGND VGND VPWR VPWR _6109_/Q sky130_fd_sc_hd__dfrtp_4
XFILLER_27_653 VGND VGND VPWR VPWR sky130_fd_sc_hd__fill_1
XANTENNA_fanout58_A _5055_/S VGND VGND VPWR VPWR sky130_fd_sc_hd__diode_2
XTAP_TAPCELL_ROW_65_990 VGND VPWR sky130_fd_sc_hd__tapvpwrvgnd_1
XFILLER_25_53 VGND VGND VPWR VPWR sky130_fd_sc_hd__decap_3
XANTENNA__5167__S _5167_/S VGND VGND VPWR VPWR sky130_fd_sc_hd__diode_2
XFILLER_10_553 VGND VGND VPWR VPWR sky130_fd_sc_hd__fill_1
XANTENNA__3922__B1 _3548_/Y VGND VGND VPWR VPWR sky130_fd_sc_hd__diode_2
XFILLER_1_251 VPWR VGND VPWR VGND sky130_ef_sc_hd__decap_12
XTAP_TAPCELL_ROW_69_1048 VGND VPWR sky130_fd_sc_hd__tapvpwrvgnd_1
XTAP_TAPCELL_ROW_69_1037 VGND VPWR sky130_fd_sc_hd__tapvpwrvgnd_1
XANTENNA__4650__A1 _5796_/Q VGND VGND VPWR VPWR sky130_fd_sc_hd__diode_2
XTAP_TAPCELL_ROW_35_618 VGND VPWR sky130_fd_sc_hd__tapvpwrvgnd_1
X_4790_ _5490_/Q hold280/X _4807_/S VGND VGND VPWR VPWR _5827_/D sky130_fd_sc_hd__mux2_1
X_3810_ _3810_/A _3810_/B VGND VGND VPWR VPWR _3810_/X sky130_fd_sc_hd__and2_1
XFILLER_60_475 VGND VGND VPWR VPWR sky130_fd_sc_hd__fill_1
X_3741_ _5566_/Q _5567_/Q _4164_/A VGND VGND VPWR VPWR _3741_/X sky130_fd_sc_hd__o21a_1
XTAP_TAPCELL_ROW_15_364 VGND VPWR sky130_fd_sc_hd__tapvpwrvgnd_1
XFILLER_20_328 VGND VGND VPWR VPWR sky130_fd_sc_hd__fill_1
XANTENNA__5077__S _5097_/S VGND VGND VPWR VPWR sky130_fd_sc_hd__diode_2
XFILLER_70_3 VPWR VGND VPWR VGND sky130_ef_sc_hd__decap_12
XFILLER_9_362 VGND VGND VPWR VPWR sky130_fd_sc_hd__decap_6
X_3672_ _6105_/Q _4491_/A _3584_/B _3584_/C _3591_/X VGND VGND VPWR VPWR _3709_/C
+ sky130_fd_sc_hd__a2111o_1
X_5411_ _5406_/A _5441_/B _5410_/X VGND VGND VPWR VPWR _6169_/D sky130_fd_sc_hd__a21o_1
X_5342_ _6160_/Q _5342_/B _5342_/C VGND VGND VPWR VPWR _5342_/X sky130_fd_sc_hd__and3_1
X_5273_ _6149_/Q _5285_/B VGND VGND VPWR VPWR _5274_/B sky130_fd_sc_hd__nor2_1
X_4224_ _5941_/Q _4177_/C _4176_/C _5908_/Q VGND VGND VPWR VPWR _4224_/X sky130_fd_sc_hd__a22o_1
X_4155_ _4155_/A _4155_/B _4155_/C VGND VGND VPWR VPWR _4157_/B sky130_fd_sc_hd__or3_1
X_3106_ _5684_/Q _3104_/B _3104_/A VGND VGND VPWR VPWR _3106_/Y sky130_fd_sc_hd__a21oi_1
X_4086_ _5584_/Q hold63/X _4091_/S VGND VGND VPWR VPWR _5693_/D sky130_fd_sc_hd__mux2_1
X_3037_ _5959_/Q _2971_/X _2973_/X _5967_/Q _2968_/X VGND VGND VPWR VPWR _3037_/X
+ sky130_fd_sc_hd__a221o_1
XANTENNA__6052__RESET_B fanout283/X VGND VGND VPWR VPWR sky130_fd_sc_hd__diode_2
XFILLER_23_111 VGND VGND VPWR VPWR sky130_fd_sc_hd__fill_1
XTAP_TAPCELL_ROW_62_960 VGND VPWR sky130_fd_sc_hd__tapvpwrvgnd_1
XFILLER_62_29 VGND VGND VPWR VPWR sky130_fd_sc_hd__decap_3
XFILLER_23_133 VGND VGND VPWR VPWR sky130_fd_sc_hd__fill_2
XFILLER_23_155 VGND VGND VPWR VPWR sky130_fd_sc_hd__decap_3
X_4988_ _4211_/X _4979_/A _4979_/B _4892_/X VGND VGND VPWR VPWR _4988_/X sky130_fd_sc_hd__a22o_1
XANTENNA__4944__A2 _4878_/A VGND VGND VPWR VPWR sky130_fd_sc_hd__diode_2
X_3939_ _5597_/Q _3536_/Y _3940_/S VGND VGND VPWR VPWR _5597_/D sky130_fd_sc_hd__mux2_1
X_5609_ _5635_/CLK _5609_/D fanout315/X VGND VGND VPWR VPWR _5609_/Q sky130_fd_sc_hd__dfrtp_1
XFILLER_11_55 VGND VGND VPWR VPWR sky130_fd_sc_hd__fill_1
XFILLER_3_505 VGND VGND VPWR VPWR sky130_fd_sc_hd__decap_4
Xfanout330 fanout334/X VGND VGND VPWR VPWR fanout330/X sky130_fd_sc_hd__clkbuf_4
Xfanout341 fanout352/X VGND VGND VPWR VPWR fanout341/X sky130_fd_sc_hd__clkbuf_4
XANTENNA__3462__C _6130_/D VGND VGND VPWR VPWR sky130_fd_sc_hd__diode_2
Xfanout352 input1/X VGND VGND VPWR VPWR fanout352/X sky130_fd_sc_hd__buf_2
XANTENNA__4880__A1 _5517_/Q VGND VGND VPWR VPWR sky130_fd_sc_hd__diode_2
XFILLER_19_417 VGND VGND VPWR VPWR sky130_fd_sc_hd__decap_6
XANTENNA__2891__B1 _2916_/B VGND VGND VPWR VPWR sky130_fd_sc_hd__diode_2
XFILLER_36_41 VGND VGND VPWR VPWR sky130_fd_sc_hd__fill_2
XANTENNA__4632__B2 _4672_/A1 VGND VGND VPWR VPWR sky130_fd_sc_hd__diode_2
XFILLER_15_667 VGND VGND VPWR VPWR sky130_fd_sc_hd__fill_2
XANTENNA__3199__A1 _5470_/Q VGND VGND VPWR VPWR sky130_fd_sc_hd__diode_2
XANTENNA__4935__A2 _4950_/A2 VGND VGND VPWR VPWR sky130_fd_sc_hd__diode_2
XFILLER_52_62 VGND VGND VPWR VPWR sky130_fd_sc_hd__decap_3
XTAP_TAPCELL_ROW_12_334 VGND VPWR sky130_fd_sc_hd__tapvpwrvgnd_1
XTAP_TAPCELL_ROW_40_676 VGND VPWR sky130_fd_sc_hd__tapvpwrvgnd_1
XFILLER_6_365 VGND VGND VPWR VPWR sky130_fd_sc_hd__decap_4
XANTENNA__3123__A1 _5488_/Q VGND VGND VPWR VPWR sky130_fd_sc_hd__diode_2
XANTENNA__4871__A1 _5719_/Q VGND VGND VPWR VPWR sky130_fd_sc_hd__diode_2
XFILLER_37_203 VPWR VGND VPWR VGND sky130_ef_sc_hd__decap_12
XANTENNA__2882__B1 _2886_/B VGND VGND VPWR VPWR sky130_fd_sc_hd__diode_2
XFILLER_65_534 VGND VGND VPWR VPWR sky130_fd_sc_hd__fill_1
X_5960_ _5966_/CLK _5960_/D fanout308/X VGND VGND VPWR VPWR _5960_/Q sky130_fd_sc_hd__dfrtp_1
XANTENNA__4623__A1 _5767_/Q VGND VGND VPWR VPWR sky130_fd_sc_hd__diode_2
XTAP_TAPCELL_ROW_48_776 VGND VPWR sky130_fd_sc_hd__tapvpwrvgnd_1
X_5891_ _6094_/CLK _5891_/D fanout345/X VGND VGND VPWR VPWR _5891_/Q sky130_fd_sc_hd__dfrtp_1
X_4911_ _4583_/X _4950_/A2 _4950_/B1 _4910_/X VGND VGND VPWR VPWR _4911_/X sky130_fd_sc_hd__a22o_1
XFILLER_45_291 VGND VGND VPWR VPWR sky130_fd_sc_hd__fill_1
X_4842_ _5488_/Q hold325/X _4862_/S VGND VGND VPWR VPWR _5876_/D sky130_fd_sc_hd__mux2_1
XFILLER_21_626 VGND VGND VPWR VPWR sky130_fd_sc_hd__fill_1
XANTENNA__4926__A2 _4950_/A2 VGND VGND VPWR VPWR sky130_fd_sc_hd__diode_2
X_4773_ hold122/X _3866_/X _4776_/S VGND VGND VPWR VPWR _5811_/D sky130_fd_sc_hd__mux2_1
X_3724_ _3475_/Y _3663_/B _5198_/B _3723_/X _3663_/A VGND VGND VPWR VPWR _3724_/X
+ sky130_fd_sc_hd__o311a_1
X_3655_ _3656_/A _6041_/Q VGND VGND VPWR VPWR _3658_/B sky130_fd_sc_hd__nor2_1
XANTENNA_fanout108_A _4878_/Y VGND VGND VPWR VPWR sky130_fd_sc_hd__diode_2
X_3586_ _6100_/Q _4427_/A VGND VGND VPWR VPWR _3707_/B sky130_fd_sc_hd__xor2_1
X_5325_ _5326_/A _5326_/B VGND VGND VPWR VPWR _5325_/X sky130_fd_sc_hd__and2_1
X_5256_ _5256_/A _5256_/B _5256_/C VGND VGND VPWR VPWR _5257_/B sky130_fd_sc_hd__and3_1
X_4207_ _4206_/X _4202_/X _4234_/S VGND VGND VPWR VPWR _4207_/X sky130_fd_sc_hd__mux2_1
X_5187_ _6109_/Q _5187_/B VGND VGND VPWR VPWR _5188_/B sky130_fd_sc_hd__xnor2_1
X_4138_ _4138_/A _4158_/B VGND VGND VPWR VPWR _4151_/B sky130_fd_sc_hd__or2_1
XANTENNA__4614__A1 _4686_/A1 VGND VGND VPWR VPWR sky130_fd_sc_hd__diode_2
X_4069_ _4074_/S1 _4069_/B VGND VGND VPWR VPWR _4069_/X sky130_fd_sc_hd__and2b_1
XFILLER_24_431 VPWR VGND VPWR VGND sky130_ef_sc_hd__decap_12
XFILLER_11_169 VGND VGND VPWR VPWR sky130_fd_sc_hd__decap_8
XFILLER_20_681 VGND VGND VPWR VPWR sky130_fd_sc_hd__fill_2
XFILLER_22_76 VGND VGND VPWR VPWR sky130_fd_sc_hd__fill_1
XFILLER_0_3 VPWR VGND VPWR VGND sky130_ef_sc_hd__decap_12
XANTENNA__4550__B1 _4829_/B VGND VGND VPWR VPWR sky130_fd_sc_hd__diode_2
Xfanout182 _2787_/X VGND VGND VPWR VPWR _2921_/A2 sky130_fd_sc_hd__dlymetal6s2s_1
Xfanout160 _4618_/S VGND VGND VPWR VPWR _4610_/S sky130_fd_sc_hd__clkbuf_4
Xfanout171 _2964_/B VGND VGND VPWR VPWR _3397_/A2 sky130_fd_sc_hd__dlymetal6s2s_1
XFILLER_19_225 VGND VGND VPWR VPWR sky130_fd_sc_hd__fill_1
Xfanout193 _6166_/Q VGND VGND VPWR VPWR _5200_/C sky130_fd_sc_hd__clkbuf_4
XANTENNA__2817__B _2964_/B VGND VGND VPWR VPWR sky130_fd_sc_hd__diode_2
XTAP_TAPCELL_ROW_66_1007 VGND VPWR sky130_fd_sc_hd__tapvpwrvgnd_1
XFILLER_62_537 VGND VGND VPWR VPWR sky130_fd_sc_hd__fill_1
XANTENNA__4605__A1 _5765_/Q VGND VGND VPWR VPWR sky130_fd_sc_hd__diode_2
XFILLER_15_420 VPWR VGND VPWR VGND sky130_ef_sc_hd__decap_12
XTAP_TAPCELL_ROW_45_746 VGND VPWR sky130_fd_sc_hd__tapvpwrvgnd_1
XANTENNA__3929__A _6129_/D VGND VGND VPWR VPWR sky130_fd_sc_hd__diode_2
XFILLER_42_250 VGND VGND VPWR VPWR sky130_fd_sc_hd__fill_2
XANTENNA__4908__A2 _4950_/A2 VGND VGND VPWR VPWR sky130_fd_sc_hd__diode_2
XANTENNA__4369__B1 _5737_/Q VGND VGND VPWR VPWR sky130_fd_sc_hd__diode_2
XTAP_TAPCELL_ROW_25_492 VGND VPWR sky130_fd_sc_hd__tapvpwrvgnd_1
XFILLER_30_489 VGND VGND VPWR VPWR sky130_fd_sc_hd__fill_1
XFILLER_7_641 VGND VGND VPWR VPWR sky130_fd_sc_hd__decap_3
XTAP_TAPCELL_ROW_77_1147 VGND VPWR sky130_fd_sc_hd__tapvpwrvgnd_1
XFILLER_6_195 VGND VGND VPWR VPWR sky130_fd_sc_hd__fill_1
X_3440_ hold30/X _5587_/Q _3442_/S VGND VGND VPWR VPWR _5554_/D sky130_fd_sc_hd__mux2_1
X_3371_ hold97/X _2964_/B _5109_/S VGND VGND VPWR VPWR _5503_/D sky130_fd_sc_hd__a21o_1
X_6090_ _6094_/CLK _6090_/D fanout349/X VGND VGND VPWR VPWR _6090_/Q sky130_fd_sc_hd__dfrtp_1
XFILLER_33_3 VGND VGND VPWR VPWR sky130_fd_sc_hd__decap_6
X_5110_ hold390/X _5447_/A _5127_/B VGND VGND VPWR VPWR _6033_/D sky130_fd_sc_hd__mux2_1
X_5041_ _5966_/Q _5041_/A2 _5040_/X VGND VGND VPWR VPWR _5966_/D sky130_fd_sc_hd__a21o_1
XANTENNA__5097__A1 _5476_/Q VGND VGND VPWR VPWR sky130_fd_sc_hd__diode_2
XANTENNA__5090__S _5098_/S VGND VGND VPWR VPWR sky130_fd_sc_hd__diode_2
XFILLER_38_556 VGND VGND VPWR VPWR sky130_fd_sc_hd__decap_3
XFILLER_65_353 VGND VGND VPWR VPWR sky130_fd_sc_hd__fill_1
X_5943_ _5965_/CLK _5943_/D fanout303/X VGND VGND VPWR VPWR _5943_/Q sky130_fd_sc_hd__dfrtp_1
X_5874_ _6091_/CLK _5874_/D fanout347/X VGND VGND VPWR VPWR _5874_/Q sky130_fd_sc_hd__dfrtp_1
XFILLER_33_272 VGND VGND VPWR VPWR sky130_fd_sc_hd__decap_8
X_4825_ _4873_/A _4873_/B _4825_/C VGND VGND VPWR VPWR _5116_/S sky130_fd_sc_hd__and3b_1
XFILLER_21_445 VGND VGND VPWR VPWR sky130_fd_sc_hd__decap_3
X_4756_ _5795_/Q _4761_/A2 _4828_/B2 _3559_/Y VGND VGND VPWR VPWR _5795_/D sky130_fd_sc_hd__a22o_1
X_4687_ _5926_/Q _5767_/Q _4687_/S VGND VGND VPWR VPWR _4687_/X sky130_fd_sc_hd__mux2_1
X_3707_ _3707_/A _3707_/B _3707_/C _3674_/Y VGND VGND VPWR VPWR _3711_/C sky130_fd_sc_hd__or4b_1
X_3638_ _3720_/A _3720_/B _3638_/C _5861_/Q VGND VGND VPWR VPWR _3660_/A sky130_fd_sc_hd__or4b_1
X_3569_ _4354_/S _4499_/A VGND VGND VPWR VPWR _4539_/A sky130_fd_sc_hd__or2_2
XFILLER_0_305 VGND VGND VPWR VPWR sky130_fd_sc_hd__decap_3
X_5308_ _6154_/Q _5341_/B2 _5327_/C _5307_/X VGND VGND VPWR VPWR _6154_/D sky130_fd_sc_hd__a22o_1
XANTENNA__5088__A1 _5471_/Q VGND VGND VPWR VPWR sky130_fd_sc_hd__diode_2
XFILLER_48_309 VGND VGND VPWR VPWR sky130_fd_sc_hd__fill_1
X_5239_ _4344_/D _5211_/A _4344_/A VGND VGND VPWR VPWR _5256_/C sky130_fd_sc_hd__a21oi_1
XFILLER_17_65 VGND VGND VPWR VPWR sky130_fd_sc_hd__decap_6
XFILLER_17_87 VGND VGND VPWR VPWR sky130_fd_sc_hd__fill_1
XFILLER_52_570 VGND VGND VPWR VPWR sky130_fd_sc_hd__fill_1
XTAP_TAPCELL_ROW_42_705 VGND VPWR sky130_fd_sc_hd__tapvpwrvgnd_1
XANTENNA__5737__Q _5737_/Q VGND VGND VPWR VPWR sky130_fd_sc_hd__diode_2
XPHY_EDGE_ROW_49_Left_130 VGND VGND VPWR VPWR sky130_fd_sc_hd__decap_3
XTAP_TAPCELL_ROW_22_451 VGND VPWR sky130_fd_sc_hd__tapvpwrvgnd_1
XANTENNA__5472__Q _5472_/Q VGND VGND VPWR VPWR sky130_fd_sc_hd__diode_2
XANTENNA__4523__B1 _4522_/C VGND VGND VPWR VPWR sky130_fd_sc_hd__diode_2
XFILLER_79_401 VGND VGND VPWR VPWR sky130_fd_sc_hd__fill_1
Xtt_um_bfcpu_366 VGND VGND VPWR VPWR tt_um_bfcpu_366/HI uo_out[4] sky130_fd_sc_hd__conb_1
Xtt_um_bfcpu_355 VGND VGND VPWR VPWR tt_um_bfcpu_355/HI uio_out[0] sky130_fd_sc_hd__conb_1
XANTENNA__5079__A1 _5490_/Q VGND VGND VPWR VPWR sky130_fd_sc_hd__diode_2
XTAP_TAPCELL_ROW_72_1077 VGND VPWR sky130_fd_sc_hd__tapvpwrvgnd_1
Xhold5 hold5/A VGND VGND VPWR VPWR hold5/X sky130_fd_sc_hd__dlygate4sd3_1
X_2940_ _2934_/A _5524_/Q _2834_/C _2833_/A VGND VGND VPWR VPWR _2940_/X sky130_fd_sc_hd__a211o_1
X_2871_ _2864_/A _2871_/B _2871_/C _6076_/Q VGND VGND VPWR VPWR _2871_/X sky130_fd_sc_hd__and4b_1
X_4610_ _5493_/Q _5799_/Q _4610_/S VGND VGND VPWR VPWR _4610_/X sky130_fd_sc_hd__mux2_1
XFILLER_30_253 VPWR VGND VPWR VGND sky130_ef_sc_hd__decap_12
X_5590_ _5635_/CLK _5590_/D fanout310/X VGND VGND VPWR VPWR _5590_/Q sky130_fd_sc_hd__dfrtp_1
XANTENNA__5085__S _5096_/S VGND VGND VPWR VPWR sky130_fd_sc_hd__diode_2
X_4541_ hold15/A _5660_/Q _4541_/S VGND VGND VPWR VPWR _4542_/B sky130_fd_sc_hd__mux2_1
Xmax_cap135 _4250_/A VGND VGND VPWR VPWR _4308_/A2 sky130_fd_sc_hd__clkbuf_2
Xhold427 _5688_/Q VGND VGND VPWR VPWR hold427/X sky130_fd_sc_hd__dlygate4sd3_1
Xhold405 _5655_/Q VGND VGND VPWR VPWR hold405/X sky130_fd_sc_hd__dlygate4sd3_1
X_4472_ _4499_/A _4472_/B VGND VGND VPWR VPWR _4472_/Y sky130_fd_sc_hd__nand2_1
Xhold416 _6023_/Q VGND VGND VPWR VPWR hold416/X sky130_fd_sc_hd__dlygate4sd3_1
Xhold438 _5933_/Q VGND VGND VPWR VPWR hold438/X sky130_fd_sc_hd__dlygate4sd3_1
X_3423_ _5640_/Q hold72/X _3961_/A VGND VGND VPWR VPWR _5538_/D sky130_fd_sc_hd__mux2_1
Xhold449 _6149_/Q VGND VGND VPWR VPWR hold449/X sky130_fd_sc_hd__dlygate4sd3_1
X_6142_ _6142_/CLK _6142_/D fanout329/X VGND VGND VPWR VPWR _6142_/Q sky130_fd_sc_hd__dfrtp_1
X_3354_ _3354_/A _3354_/B _3354_/C _3354_/D VGND VGND VPWR VPWR _3359_/B sky130_fd_sc_hd__or4_1
X_6073_ _6085_/CLK _6073_/D fanout333/X VGND VGND VPWR VPWR _6073_/Q sky130_fd_sc_hd__dfrtp_1
XANTENNA__4817__A1 _4447_/B VGND VGND VPWR VPWR sky130_fd_sc_hd__diode_2
X_3285_ _5200_/C _6024_/Q VGND VGND VPWR VPWR _3357_/D sky130_fd_sc_hd__and2b_1
X_5024_ _4677_/X _5024_/A2 _5024_/B1 _4946_/X VGND VGND VPWR VPWR _5024_/X sky130_fd_sc_hd__a22o_1
XFILLER_54_19 VGND VGND VPWR VPWR sky130_fd_sc_hd__fill_1
XFILLER_38_386 VPWR VGND VPWR VGND sky130_ef_sc_hd__decap_12
XTAP_TAPCELL_ROW_0_168 VGND VPWR sky130_fd_sc_hd__tapvpwrvgnd_1
XTAP_TAPCELL_ROW_0_179 VGND VPWR sky130_fd_sc_hd__tapvpwrvgnd_1
XANTENNA__2744__Y _4452_/A VGND VGND VPWR VPWR sky130_fd_sc_hd__diode_2
XANTENNA_fanout342_A fanout351/X VGND VGND VPWR VPWR sky130_fd_sc_hd__diode_2
X_5926_ _5967_/CLK _5926_/D fanout307/X VGND VGND VPWR VPWR _5926_/Q sky130_fd_sc_hd__dfrtp_1
X_5857_ _6026_/CLK _5857_/D fanout279/X VGND VGND VPWR VPWR _5857_/Q sky130_fd_sc_hd__dfrtp_1
X_5788_ _5788_/CLK _5788_/D fanout297/X VGND VGND VPWR VPWR _5788_/Q sky130_fd_sc_hd__dfrtp_1
X_4808_ _4967_/A0 hold238/X _4810_/S VGND VGND VPWR VPWR _5845_/D sky130_fd_sc_hd__mux2_1
XFILLER_21_286 VGND VGND VPWR VPWR sky130_fd_sc_hd__fill_1
XANTENNA_fanout228_X _4943_/S VGND VGND VPWR VPWR sky130_fd_sc_hd__diode_2
X_4739_ _5933_/Q _5123_/B _4747_/B1 _4738_/X VGND VGND VPWR VPWR _4739_/X sky130_fd_sc_hd__a22o_1
XTAP_TAPCELL_ROW_8_279 VGND VPWR sky130_fd_sc_hd__tapvpwrvgnd_1
XFILLER_0_113 VPWR VGND VPWR VGND sky130_ef_sc_hd__decap_12
XFILLER_72_632 VGND VGND VPWR VPWR sky130_fd_sc_hd__fill_1
XFILLER_29_375 VPWR VGND VPWR VGND sky130_ef_sc_hd__decap_12
XANTENNA_fanout43_X _4747_/B1 VGND VGND VPWR VPWR sky130_fd_sc_hd__diode_2
XTAP_TAPCELL_ROW_27_521 VGND VPWR sky130_fd_sc_hd__tapvpwrvgnd_1
XFILLER_71_153 VGND VGND VPWR VPWR sky130_fd_sc_hd__fill_1
XTAP_TAPCELL_ROW_55_863 VGND VPWR sky130_fd_sc_hd__tapvpwrvgnd_1
XFILLER_32_507 VGND VGND VPWR VPWR sky130_fd_sc_hd__fill_2
XANTENNA__5467__Q _5467_/Q VGND VGND VPWR VPWR sky130_fd_sc_hd__diode_2
XFILLER_44_85 VGND VGND VPWR VPWR sky130_fd_sc_hd__decap_6
XFILLER_12_253 VGND VGND VPWR VPWR sky130_fd_sc_hd__fill_2
XANTENNA__4802__S _4810_/S VGND VGND VPWR VPWR sky130_fd_sc_hd__diode_2
XTAP_TAPCELL_ROW_74_1106 VGND VPWR sky130_fd_sc_hd__tapvpwrvgnd_1
XFILLER_5_57 VGND VGND VPWR VPWR sky130_fd_sc_hd__fill_2
X_3070_ _5606_/Q _5655_/Q VGND VGND VPWR VPWR _3070_/X sky130_fd_sc_hd__or2_1
XFILLER_54_109 VGND VGND VPWR VPWR sky130_fd_sc_hd__decap_8
XANTENNA__4680__C1 _4720_/C1 VGND VGND VPWR VPWR sky130_fd_sc_hd__diode_2
XFILLER_35_334 VGND VGND VPWR VPWR sky130_fd_sc_hd__fill_2
X_5711_ _5723_/CLK _5711_/D _3183_/B VGND VGND VPWR VPWR _5711_/Q sky130_fd_sc_hd__dfrtp_1
X_3972_ _5618_/Q _3976_/B _3976_/A VGND VGND VPWR VPWR _3972_/Y sky130_fd_sc_hd__a21oi_1
X_2923_ _5886_/Q _2895_/C _2910_/B _5882_/Q VGND VGND VPWR VPWR _2923_/X sky130_fd_sc_hd__a22o_1
X_2854_ _6113_/Q _5833_/Q _2783_/B _2921_/A2 _5841_/Q VGND VGND VPWR VPWR _2856_/B
+ sky130_fd_sc_hd__a32o_1
X_5642_ _5690_/CLK _5642_/D VGND VGND VPWR VPWR _5642_/Q sky130_fd_sc_hd__dfxtp_1
XANTENNA__4735__A0 _5765_/Q VGND VGND VPWR VPWR sky130_fd_sc_hd__diode_2
X_2785_ _2803_/A _6115_/Q VGND VGND VPWR VPWR _2785_/X sky130_fd_sc_hd__and2_1
X_5573_ _5811_/CLK _5573_/D fanout288/X VGND VGND VPWR VPWR _5573_/Q sky130_fd_sc_hd__dfrtp_2
X_4524_ _4536_/B _4524_/B VGND VGND VPWR VPWR _4524_/X sky130_fd_sc_hd__and2b_1
Xhold202 _5512_/Q VGND VGND VPWR VPWR hold202/X sky130_fd_sc_hd__dlygate4sd3_1
Xhold213 _6082_/Q VGND VGND VPWR VPWR hold213/X sky130_fd_sc_hd__dlygate4sd3_1
Xhold224 _5777_/Q VGND VGND VPWR VPWR hold224/X sky130_fd_sc_hd__dlygate4sd3_1
Xhold235 _5784_/Q VGND VGND VPWR VPWR hold235/X sky130_fd_sc_hd__dlygate4sd3_1
Xhold257 _5843_/Q VGND VGND VPWR VPWR hold257/X sky130_fd_sc_hd__dlygate4sd3_1
Xhold246 _5825_/Q VGND VGND VPWR VPWR hold246/X sky130_fd_sc_hd__dlygate4sd3_1
Xhold268 _5992_/Q VGND VGND VPWR VPWR hold268/X sky130_fd_sc_hd__dlygate4sd3_1
X_4455_ _4479_/A _4479_/B _3479_/X VGND VGND VPWR VPWR _4455_/X sky130_fd_sc_hd__o21a_1
Xhold279 _5735_/Q VGND VGND VPWR VPWR hold279/X sky130_fd_sc_hd__dlygate4sd3_1
X_3406_ _4970_/A0 _5523_/Q _3407_/S VGND VGND VPWR VPWR _5523_/D sky130_fd_sc_hd__mux2_1
X_4386_ _4382_/X _4385_/X _4386_/S VGND VGND VPWR VPWR _4386_/X sky130_fd_sc_hd__mux2_1
XANTENNA__3571__B _4452_/A VGND VGND VPWR VPWR sky130_fd_sc_hd__diode_2
X_6125_ _6161_/CLK _6125_/D fanout311/X VGND VGND VPWR VPWR _6125_/Q sky130_fd_sc_hd__dfrtp_2
X_3337_ _3354_/A _3355_/A _3355_/C VGND VGND VPWR VPWR _3338_/D sky130_fd_sc_hd__or3_1
XANTENNA_fanout292_A fanout298/X VGND VGND VPWR VPWR sky130_fd_sc_hd__diode_2
XTAP_TAPCELL_ROW_5_238 VGND VPWR sky130_fd_sc_hd__tapvpwrvgnd_1
X_6056_ _6061_/CLK _6056_/D fanout283/X VGND VGND VPWR VPWR _6056_/Q sky130_fd_sc_hd__dfrtp_1
X_3268_ _5231_/A _3268_/B _3268_/C _3268_/D VGND VGND VPWR VPWR _3353_/B sky130_fd_sc_hd__and4b_1
X_3199_ _2934_/B _5470_/Q _3203_/S VGND VGND VPWR VPWR _5470_/D sky130_fd_sc_hd__mux2_1
XFILLER_73_429 VGND VGND VPWR VPWR sky130_fd_sc_hd__fill_1
XANTENNA_fanout178_X _2916_/B VGND VGND VPWR VPWR sky130_fd_sc_hd__diode_2
X_5007_ hold431/X _5027_/A2 _5006_/X VGND VGND VPWR VPWR _5949_/D sky130_fd_sc_hd__a21o_1
XFILLER_38_172 VPWR VGND VPWR VGND sky130_ef_sc_hd__decap_12
XFILLER_54_643 VGND VGND VPWR VPWR sky130_fd_sc_hd__fill_1
XANTENNA__3226__A0 _4964_/A0 VGND VGND VPWR VPWR sky130_fd_sc_hd__diode_2
XTAP_TAPCELL_ROW_52_833 VGND VPWR sky130_fd_sc_hd__tapvpwrvgnd_1
XFILLER_41_337 VGND VGND VPWR VPWR sky130_fd_sc_hd__fill_1
X_5909_ _5942_/CLK _5909_/D fanout306/X VGND VGND VPWR VPWR _5909_/Q sky130_fd_sc_hd__dfrtp_1
XANTENNA__4974__B1 _4878_/B VGND VGND VPWR VPWR sky130_fd_sc_hd__diode_2
XFILLER_49_426 VGND VGND VPWR VPWR sky130_fd_sc_hd__fill_1
XFILLER_39_63 VGND VGND VPWR VPWR sky130_fd_sc_hd__fill_1
XANTENNA__4880__X _4880_/X VGND VGND VPWR VPWR sky130_fd_sc_hd__diode_2
XANTENNA__5201__B _5201_/B VGND VGND VPWR VPWR sky130_fd_sc_hd__diode_2
XTAP_TAPCELL_ROW_80_1187 VGND VPWR sky130_fd_sc_hd__tapvpwrvgnd_1
XTAP_TAPCELL_ROW_80_1176 VGND VPWR sky130_fd_sc_hd__tapvpwrvgnd_1
XFILLER_71_83 VPWR VGND VPWR VGND sky130_ef_sc_hd__decap_12
XTAP_TAPCELL_ROW_80_1198 VGND VPWR sky130_fd_sc_hd__tapvpwrvgnd_1
XANTENNA__4717__A0 _5763_/Q VGND VGND VPWR VPWR sky130_fd_sc_hd__diode_2
XTAP_TAPCELL_ROW_30_549 VGND VPWR sky130_fd_sc_hd__tapvpwrvgnd_1
XANTENNA__4193__A1 _5762_/Q VGND VGND VPWR VPWR sky130_fd_sc_hd__diode_2
XANTENNA__3940__A1 _3564_/A VGND VGND VPWR VPWR sky130_fd_sc_hd__diode_2
X_4240_ _5910_/Q _5767_/Q _4241_/S VGND VGND VPWR VPWR _4240_/X sky130_fd_sc_hd__mux2_1
X_4171_ _5785_/Q _4167_/Y _4170_/Y _5777_/Q _4168_/Y VGND VGND VPWR VPWR _4171_/X
+ sky130_fd_sc_hd__a221o_1
XFILLER_67_223 VGND VGND VPWR VPWR sky130_fd_sc_hd__fill_1
X_3122_ _5912_/Q _2988_/B _3127_/B _5904_/Q _2993_/D VGND VGND VPWR VPWR _3122_/X
+ sky130_fd_sc_hd__a221o_1
XTAP_TAPCELL_ROW_2_208 VGND VPWR sky130_fd_sc_hd__tapvpwrvgnd_1
X_3053_ _3052_/Y hold367/X _3053_/S VGND VGND VPWR VPWR _5690_/D sky130_fd_sc_hd__mux2_1
XTAP_TAPCELL_ROW_38_649 VGND VPWR sky130_fd_sc_hd__tapvpwrvgnd_1
XFILLER_35_153 VGND VGND VPWR VPWR sky130_fd_sc_hd__decap_8
XFILLER_23_337 VPWR VGND VPWR VGND sky130_ef_sc_hd__decap_12
XANTENNA__4956__B1 _4878_/B VGND VGND VPWR VPWR sky130_fd_sc_hd__diode_2
X_3955_ _3955_/A _3955_/B VGND VGND VPWR VPWR _5610_/D sky130_fd_sc_hd__xor2_1
X_2906_ _2844_/D _5523_/Q _2834_/C _2844_/C VGND VGND VPWR VPWR _2906_/X sky130_fd_sc_hd__a211o_1
XFILLER_50_178 VGND VGND VPWR VPWR sky130_fd_sc_hd__fill_1
X_3886_ _5578_/Q _3885_/X _3917_/S VGND VGND VPWR VPWR _5578_/D sky130_fd_sc_hd__mux2_1
X_5625_ _5690_/CLK _5625_/D fanout315/X VGND VGND VPWR VPWR _5625_/Q sky130_fd_sc_hd__dfrtp_1
XANTENNA__4708__B1 _4243_/S VGND VGND VPWR VPWR sky130_fd_sc_hd__diode_2
X_2837_ _5751_/Q _2837_/B _5768_/Q VGND VGND VPWR VPWR _2837_/X sky130_fd_sc_hd__or3b_2
XANTENNA_fanout305_A fanout306/X VGND VGND VPWR VPWR sky130_fd_sc_hd__diode_2
XFILLER_3_709 VGND VGND VPWR VPWR sky130_fd_sc_hd__decap_4
X_2768_ _5736_/Q VGND VGND VPWR VPWR _4364_/A sky130_fd_sc_hd__inv_2
X_5556_ _6120_/CLK _5556_/D VGND VGND VPWR VPWR hold55/A sky130_fd_sc_hd__dfxtp_1
X_5487_ _6085_/CLK _5487_/D fanout332/X VGND VGND VPWR VPWR _5487_/Q sky130_fd_sc_hd__dfrtp_4
X_4507_ _4507_/A _4507_/B VGND VGND VPWR VPWR _4507_/Y sky130_fd_sc_hd__xnor2_1
X_4438_ _4444_/B _4452_/B VGND VGND VPWR VPWR _4440_/A sky130_fd_sc_hd__and2_1
X_4369_ _6109_/Q _5736_/Q _5737_/Q VGND VGND VPWR VPWR _4370_/B sky130_fd_sc_hd__a21oi_1
X_6108_ clkload3/A _6108_/D fanout274/X VGND VGND VPWR VPWR _6108_/Q sky130_fd_sc_hd__dfrtp_1
X_6039_ _6106_/CLK _6039_/D fanout275/X VGND VGND VPWR VPWR _6039_/Q sky130_fd_sc_hd__dfrtp_1
XTAP_TAPCELL_ROW_65_991 VGND VPWR sky130_fd_sc_hd__tapvpwrvgnd_1
XFILLER_14_348 VPWR VGND VPWR VGND sky130_ef_sc_hd__decap_12
XFILLER_10_587 VGND VGND VPWR VPWR sky130_fd_sc_hd__fill_1
XFILLER_6_525 VGND VGND VPWR VPWR sky130_fd_sc_hd__decap_6
XANTENNA__3922__B2 _3918_/X VGND VGND VPWR VPWR sky130_fd_sc_hd__diode_2
XFILLER_49_212 VGND VGND VPWR VPWR sky130_fd_sc_hd__decap_4
XFILLER_1_263 VPWR VGND VPWR VGND sky130_ef_sc_hd__decap_12
XFILLER_18_610 VGND VGND VPWR VPWR sky130_fd_sc_hd__decap_6
XTAP_TAPCELL_ROW_69_1038 VGND VPWR sky130_fd_sc_hd__tapvpwrvgnd_1
XFILLER_66_83 VGND VGND VPWR VPWR sky130_fd_sc_hd__fill_1
XANTENNA__3431__S _3434_/S VGND VGND VPWR VPWR sky130_fd_sc_hd__diode_2
XFILLER_18_665 VGND VGND VPWR VPWR sky130_fd_sc_hd__decap_8
XTAP_TAPCELL_ROW_35_619 VGND VPWR sky130_fd_sc_hd__tapvpwrvgnd_1
XFILLER_17_175 VGND VGND VPWR VPWR sky130_fd_sc_hd__decap_4
XFILLER_33_646 VGND VGND VPWR VPWR sky130_fd_sc_hd__fill_2
XANTENNA__4938__B1 _4950_/B1 VGND VGND VPWR VPWR sky130_fd_sc_hd__diode_2
X_3740_ _5566_/Q _5567_/Q VGND VGND VPWR VPWR _3740_/Y sky130_fd_sc_hd__nand2_1
XTAP_TAPCELL_ROW_15_365 VGND VPWR sky130_fd_sc_hd__tapvpwrvgnd_1
X_3671_ _3711_/A _3708_/D _3710_/A _3671_/D VGND VGND VPWR VPWR _3676_/B sky130_fd_sc_hd__or4_1
XFILLER_63_3 VGND VGND VPWR VPWR sky130_fd_sc_hd__decap_8
X_5410_ _5415_/B _5410_/B _5410_/C VGND VGND VPWR VPWR _5410_/X sky130_fd_sc_hd__and3b_1
X_5341_ _5339_/X _5340_/Y hold415/X _5341_/B2 VGND VGND VPWR VPWR _6159_/D sky130_fd_sc_hd__a2bb2o_1
XANTENNA__5093__S _5097_/S VGND VGND VPWR VPWR sky130_fd_sc_hd__diode_2
X_5272_ _6149_/Q _5285_/B VGND VGND VPWR VPWR _5274_/A sky130_fd_sc_hd__and2_1
X_4223_ _5908_/Q _5765_/Q _4241_/S VGND VGND VPWR VPWR _4223_/X sky130_fd_sc_hd__mux2_1
X_4154_ _6177_/Q _5458_/B VGND VGND VPWR VPWR _4155_/C sky130_fd_sc_hd__nor2_1
XFILLER_68_587 VGND VGND VPWR VPWR sky130_fd_sc_hd__fill_1
X_3105_ hold375/X _3101_/B _3104_/Y VGND VGND VPWR VPWR _5683_/D sky130_fd_sc_hd__o21a_1
X_4085_ _5583_/Q hold95/X _4091_/S VGND VGND VPWR VPWR _5692_/D sky130_fd_sc_hd__mux2_1
X_3036_ hold350/X _3035_/X _3114_/S VGND VGND VPWR VPWR _6123_/D sky130_fd_sc_hd__mux2_1
XFILLER_63_281 VGND VGND VPWR VPWR sky130_fd_sc_hd__fill_1
XTAP_TAPCELL_ROW_62_961 VGND VPWR sky130_fd_sc_hd__tapvpwrvgnd_1
XTAP_TAPCELL_ROW_62_950 VGND VPWR sky130_fd_sc_hd__tapvpwrvgnd_1
XANTENNA_clkbuf_leaf_24_clk_A clkload2/A VGND VGND VPWR VPWR sky130_fd_sc_hd__diode_2
X_4987_ hold437/X _5041_/A2 _4986_/X VGND VGND VPWR VPWR _5939_/D sky130_fd_sc_hd__a21o_1
X_3938_ _5596_/Q _3541_/Y _3940_/S VGND VGND VPWR VPWR _5596_/D sky130_fd_sc_hd__mux2_1
XANTENNA__3296__B _5406_/A VGND VGND VPWR VPWR sky130_fd_sc_hd__diode_2
XANTENNA__2955__A2 _3426_/D VGND VGND VPWR VPWR sky130_fd_sc_hd__diode_2
XANTENNA__3285__A_N _5200_/C VGND VGND VPWR VPWR sky130_fd_sc_hd__diode_2
X_3869_ _5201_/B _3869_/B _3893_/C VGND VGND VPWR VPWR _3869_/X sky130_fd_sc_hd__and3_1
X_5608_ _5686_/CLK _5608_/D fanout322/X VGND VGND VPWR VPWR _5608_/Q sky130_fd_sc_hd__dfstp_1
X_5539_ _6149_/CLK _5539_/D VGND VGND VPWR VPWR hold79/A sky130_fd_sc_hd__dfxtp_1
XANTENNA_clkbuf_leaf_39_clk_A clkload1/A VGND VGND VPWR VPWR sky130_fd_sc_hd__diode_2
XFILLER_3_539 VGND VGND VPWR VPWR sky130_fd_sc_hd__fill_1
Xfanout331 fanout334/X VGND VGND VPWR VPWR fanout331/X sky130_fd_sc_hd__clkbuf_4
XPHY_EDGE_ROW_21_Left_102 VGND VGND VPWR VPWR sky130_fd_sc_hd__decap_3
XANTENNA__3462__D _6129_/D VGND VGND VPWR VPWR sky130_fd_sc_hd__diode_2
Xfanout320 fanout323/X VGND VGND VPWR VPWR fanout320/X sky130_fd_sc_hd__clkbuf_2
Xfanout342 fanout351/X VGND VGND VPWR VPWR fanout342/X sky130_fd_sc_hd__clkbuf_4
XANTENNA__2876__D1 _6114_/Q VGND VGND VPWR VPWR sky130_fd_sc_hd__diode_2
XANTENNA_fanout70_A _4740_/A2 VGND VGND VPWR VPWR sky130_fd_sc_hd__diode_2
XFILLER_19_407 VGND VGND VPWR VPWR sky130_fd_sc_hd__decap_6
XFILLER_36_31 VGND VGND VPWR VPWR sky130_fd_sc_hd__fill_1
XANTENNA__2943__X _6131_/D VGND VGND VPWR VPWR sky130_fd_sc_hd__diode_2
XFILLER_42_410 VGND VGND VPWR VPWR sky130_fd_sc_hd__decap_8
XFILLER_42_421 VGND VGND VPWR VPWR sky130_fd_sc_hd__fill_2
XPHY_EDGE_ROW_30_Left_111 VGND VGND VPWR VPWR sky130_fd_sc_hd__decap_3
XANTENNA__3738__A4 _4865_/A VGND VGND VPWR VPWR sky130_fd_sc_hd__diode_2
XTAP_TAPCELL_ROW_12_335 VGND VPWR sky130_fd_sc_hd__tapvpwrvgnd_1
XTAP_TAPCELL_ROW_12_324 VGND VPWR sky130_fd_sc_hd__tapvpwrvgnd_1
XANTENNA__5475__Q _5475_/Q VGND VGND VPWR VPWR sky130_fd_sc_hd__diode_2
XTAP_TAPCELL_ROW_40_677 VGND VPWR sky130_fd_sc_hd__tapvpwrvgnd_1
XANTENNA__4810__S _4810_/S VGND VGND VPWR VPWR sky130_fd_sc_hd__diode_2
XANTENNA__4699__A2 _5055_/S VGND VGND VPWR VPWR sky130_fd_sc_hd__diode_2
XANTENNA__3371__A2 _2964_/B VGND VGND VPWR VPWR sky130_fd_sc_hd__diode_2
XFILLER_77_71 VPWR VGND VPWR VGND sky130_ef_sc_hd__decap_12
XFILLER_77_60 VGND VGND VPWR VPWR sky130_fd_sc_hd__decap_3
XANTENNA__3123__A2 _5468_/Q VGND VGND VPWR VPWR sky130_fd_sc_hd__diode_2
XFILLER_77_384 VGND VGND VPWR VPWR sky130_fd_sc_hd__decap_8
XFILLER_77_362 VGND VGND VPWR VPWR sky130_fd_sc_hd__decap_8
XFILLER_37_215 VGND VGND VPWR VPWR sky130_fd_sc_hd__decap_4
XANTENNA__4608__C1 _4704_/C1 VGND VGND VPWR VPWR sky130_fd_sc_hd__diode_2
XTAP_TAPCELL_ROW_48_777 VGND VPWR sky130_fd_sc_hd__tapvpwrvgnd_1
XFILLER_18_462 VGND VGND VPWR VPWR sky130_fd_sc_hd__fill_1
X_5890_ _6091_/CLK _5890_/D fanout348/X VGND VGND VPWR VPWR _5890_/Q sky130_fd_sc_hd__dfrtp_1
X_4910_ _5489_/Q _4578_/X _4943_/S VGND VGND VPWR VPWR _4910_/X sky130_fd_sc_hd__mux2_1
X_4841_ _5487_/Q hold273/X _4863_/S VGND VGND VPWR VPWR _5875_/D sky130_fd_sc_hd__mux2_1
XANTENNA__5088__S _5098_/S VGND VGND VPWR VPWR sky130_fd_sc_hd__diode_2
X_4772_ hold132/X _3854_/X _4774_/S VGND VGND VPWR VPWR _5810_/D sky130_fd_sc_hd__mux2_1
X_3723_ _3722_/X _3723_/B _3723_/C VGND VGND VPWR VPWR _3723_/X sky130_fd_sc_hd__and3b_1
XFILLER_20_159 VGND VGND VPWR VPWR sky130_fd_sc_hd__fill_1
XFILLER_9_171 VPWR VGND VPWR VGND sky130_ef_sc_hd__decap_12
X_3654_ _4444_/B _6038_/Q VGND VGND VPWR VPWR _3694_/B sky130_fd_sc_hd__and2b_1
X_3585_ _3707_/A _3711_/A _3708_/D _3585_/D VGND VGND VPWR VPWR _3593_/B sky130_fd_sc_hd__or4_1
X_5324_ _5315_/A _5315_/B _5319_/X _5343_/B _3467_/D VGND VGND VPWR VPWR _5326_/B
+ sky130_fd_sc_hd__a32o_1
X_5255_ _5256_/B _5256_/C _5256_/A VGND VGND VPWR VPWR _5255_/X sky130_fd_sc_hd__a21o_1
X_4206_ _5939_/Q _4177_/C _4176_/C _5906_/Q VGND VGND VPWR VPWR _4206_/X sky130_fd_sc_hd__a22o_1
X_5186_ hold433/X _4536_/A _5186_/S VGND VGND VPWR VPWR _6108_/D sky130_fd_sc_hd__mux2_1
X_4137_ _4315_/A _4329_/A VGND VGND VPWR VPWR _4137_/Y sky130_fd_sc_hd__nand2_2
XFILLER_68_384 VGND VGND VPWR VPWR sky130_fd_sc_hd__fill_1
X_4068_ hold14/A hold86/A _4070_/S VGND VGND VPWR VPWR _4069_/B sky130_fd_sc_hd__mux2_1
X_3019_ hold68/A hold46/A hold39/A hold79/A _3954_/A _3955_/A VGND VGND VPWR VPWR
+ _3019_/X sky130_fd_sc_hd__mux4_1
XFILLER_24_421 VGND VGND VPWR VPWR sky130_fd_sc_hd__fill_2
XANTENNA_fanout258_X _2843_/B VGND VGND VPWR VPWR sky130_fd_sc_hd__diode_2
XFILLER_3_325 VGND VGND VPWR VPWR sky130_fd_sc_hd__fill_2
XANTENNA__4550__B2 _5739_/Q VGND VGND VPWR VPWR sky130_fd_sc_hd__diode_2
XANTENNA__3770__A _5377_/A VGND VGND VPWR VPWR sky130_fd_sc_hd__diode_2
Xfanout183 _2786_/X VGND VGND VPWR VPWR _2910_/B sky130_fd_sc_hd__clkbuf_4
Xfanout161 _4232_/S VGND VGND VPWR VPWR _4241_/S sky130_fd_sc_hd__clkbuf_4
Xfanout172 _2816_/X VGND VGND VPWR VPWR _2964_/B sky130_fd_sc_hd__clkbuf_4
Xfanout150 _3192_/X VGND VGND VPWR VPWR _4109_/C sky130_fd_sc_hd__buf_2
XANTENNA_fanout73_X _4166_/C VGND VGND VPWR VPWR sky130_fd_sc_hd__diode_2
Xfanout194 _6165_/Q VGND VGND VPWR VPWR _5377_/A sky130_fd_sc_hd__buf_2
XTAP_TAPCELL_ROW_66_1008 VGND VPWR sky130_fd_sc_hd__tapvpwrvgnd_1
XFILLER_47_85 VGND VGND VPWR VPWR sky130_fd_sc_hd__fill_1
XANTENNA__4805__S _4805_/S VGND VGND VPWR VPWR sky130_fd_sc_hd__diode_2
XFILLER_15_432 VPWR VGND VPWR VGND sky130_ef_sc_hd__decap_12
XTAP_TAPCELL_ROW_45_747 VGND VPWR sky130_fd_sc_hd__tapvpwrvgnd_1
XANTENNA__5925__RESET_B fanout307/X VGND VGND VPWR VPWR sky130_fd_sc_hd__diode_2
XANTENNA__4369__A1 _6109_/Q VGND VGND VPWR VPWR sky130_fd_sc_hd__diode_2
XTAP_TAPCELL_ROW_25_493 VGND VPWR sky130_fd_sc_hd__tapvpwrvgnd_1
XFILLER_30_457 VGND VGND VPWR VPWR sky130_fd_sc_hd__decap_8
XANTENNA__5030__A2 _5038_/A2 VGND VGND VPWR VPWR sky130_fd_sc_hd__diode_2
XTAP_TAPCELL_ROW_77_1137 VGND VPWR sky130_fd_sc_hd__tapvpwrvgnd_1
XTAP_TAPCELL_ROW_77_1148 VGND VPWR sky130_fd_sc_hd__tapvpwrvgnd_1
X_3370_ _4175_/C _3877_/S VGND VGND VPWR VPWR _4177_/C sky130_fd_sc_hd__nor2_2
X_5040_ _4741_/X _4979_/A _4979_/B _4970_/X VGND VGND VPWR VPWR _5040_/X sky130_fd_sc_hd__a22o_1
XFILLER_26_3 VGND VGND VPWR VPWR sky130_fd_sc_hd__decap_4
XFILLER_38_513 VGND VGND VPWR VPWR sky130_fd_sc_hd__decap_3
XFILLER_26_708 VGND VGND VPWR VPWR sky130_fd_sc_hd__decap_4
X_5942_ _5942_/CLK _5942_/D fanout306/X VGND VGND VPWR VPWR _5942_/Q sky130_fd_sc_hd__dfrtp_1
X_5873_ _6085_/CLK _5873_/D fanout333/X VGND VGND VPWR VPWR _5873_/Q sky130_fd_sc_hd__dfrtp_1
XFILLER_21_413 VGND VGND VPWR VPWR sky130_fd_sc_hd__fill_2
X_4824_ _4536_/A _4824_/A2 _4824_/B1 hold101/X VGND VGND VPWR VPWR _5860_/D sky130_fd_sc_hd__a22o_1
XANTENNA__5021__A2 _5043_/A2 VGND VGND VPWR VPWR sky130_fd_sc_hd__diode_2
X_4755_ _5794_/Q _5174_/A2 _4561_/B _3554_/Y VGND VGND VPWR VPWR _5794_/D sky130_fd_sc_hd__a22o_1
XFILLER_21_457 VGND VGND VPWR VPWR sky130_fd_sc_hd__fill_1
XFILLER_21_468 VPWR VGND VPWR VGND sky130_ef_sc_hd__decap_12
X_3706_ _3475_/Y _5198_/B _3663_/A VGND VGND VPWR VPWR _3706_/X sky130_fd_sc_hd__o21a_1
X_4686_ _4686_/A1 _4685_/X _4686_/B1 VGND VGND VPWR VPWR _4686_/X sky130_fd_sc_hd__o21a_1
XANTENNA__3574__B _3623_/A VGND VGND VPWR VPWR sky130_fd_sc_hd__diode_2
X_3637_ _4873_/A _4873_/B VGND VGND VPWR VPWR _3638_/C sky130_fd_sc_hd__nand2b_1
X_3568_ _3491_/B _5206_/B _3663_/B _3663_/A VGND VGND VPWR VPWR _4499_/A sky130_fd_sc_hd__o211a_2
X_5307_ _5307_/A _5307_/B VGND VGND VPWR VPWR _5307_/X sky130_fd_sc_hd__xor2_1
X_3499_ _6122_/D _3517_/B _3492_/X _6143_/D VGND VGND VPWR VPWR _3534_/B sky130_fd_sc_hd__a22o_1
XFILLER_75_107 VGND VGND VPWR VPWR sky130_fd_sc_hd__decap_4
X_5238_ _3462_/X _3487_/B _5237_/B _5237_/A VGND VGND VPWR VPWR _5256_/B sky130_fd_sc_hd__a22o_1
X_5169_ hold225/X _5475_/Q _5170_/S VGND VGND VPWR VPWR _6091_/D sky130_fd_sc_hd__mux2_1
XANTENNA__2846__A1 _5468_/Q VGND VGND VPWR VPWR sky130_fd_sc_hd__diode_2
XANTENNA__4599__A1 _5764_/Q VGND VGND VPWR VPWR sky130_fd_sc_hd__diode_2
XFILLER_56_376 VGND VGND VPWR VPWR sky130_fd_sc_hd__fill_1
XFILLER_71_346 VGND VGND VPWR VPWR sky130_fd_sc_hd__fill_1
XFILLER_71_335 VGND VGND VPWR VPWR sky130_fd_sc_hd__fill_1
XFILLER_17_99 VPWR VGND VPWR VGND sky130_ef_sc_hd__decap_12
XANTENNA_fanout33_A _4865_/A VGND VGND VPWR VPWR sky130_fd_sc_hd__diode_2
XTAP_TAPCELL_ROW_42_706 VGND VPWR sky130_fd_sc_hd__tapvpwrvgnd_1
XANTENNA__3749__B _3877_/S VGND VGND VPWR VPWR sky130_fd_sc_hd__diode_2
XANTENNA__5012__A2 _5026_/A2 VGND VGND VPWR VPWR sky130_fd_sc_hd__diode_2
XTAP_TAPCELL_ROW_22_452 VGND VPWR sky130_fd_sc_hd__tapvpwrvgnd_1
XFILLER_4_645 VGND VGND VPWR VPWR sky130_fd_sc_hd__decap_6
XANTENNA__4523__A1 _3639_/A VGND VGND VPWR VPWR sky130_fd_sc_hd__diode_2
Xtt_um_bfcpu_356 VGND VGND VPWR VPWR tt_um_bfcpu_356/HI uio_out[1] sky130_fd_sc_hd__conb_1
XFILLER_3_166 VGND VGND VPWR VPWR sky130_fd_sc_hd__fill_2
XFILLER_3_177 VPWR VGND VPWR VGND sky130_ef_sc_hd__decap_12
Xtt_um_bfcpu_367 VGND VGND VPWR VPWR tt_um_bfcpu_367/HI uo_out[5] sky130_fd_sc_hd__conb_1
XTAP_TAPCELL_ROW_72_1078 VGND VPWR sky130_fd_sc_hd__tapvpwrvgnd_1
Xhold6 hold6/A VGND VGND VPWR VPWR hold6/X sky130_fd_sc_hd__dlygate4sd3_1
XFILLER_74_173 VGND VGND VPWR VPWR sky130_fd_sc_hd__decap_3
X_2870_ _2784_/X _2868_/X _2869_/X VGND VGND VPWR VPWR _2870_/X sky130_fd_sc_hd__a21o_1
XFILLER_30_221 VGND VGND VPWR VPWR sky130_fd_sc_hd__decap_3
XANTENNA__5003__A2 _5027_/A2 VGND VGND VPWR VPWR sky130_fd_sc_hd__diode_2
XFILLER_30_232 VGND VGND VPWR VPWR sky130_fd_sc_hd__decap_8
XFILLER_30_265 VGND VGND VPWR VPWR sky130_fd_sc_hd__decap_8
Xclkbuf_leaf_10_clk clkbuf_leaf_9_clk/A VGND VGND VPWR VPWR _5707_/CLK sky130_fd_sc_hd__clkbuf_8
X_4540_ hold387/X _5192_/A2 _4539_/X VGND VGND VPWR VPWR _5751_/D sky130_fd_sc_hd__a21o_1
Xhold406 _5947_/Q VGND VGND VPWR VPWR hold406/X sky130_fd_sc_hd__dlygate4sd3_1
Xhold417 _5768_/Q VGND VGND VPWR VPWR hold417/X sky130_fd_sc_hd__dlygate4sd3_1
X_4471_ _4487_/A _4487_/C VGND VGND VPWR VPWR _4472_/B sky130_fd_sc_hd__xnor2_1
Xhold439 _5913_/Q VGND VGND VPWR VPWR hold439/X sky130_fd_sc_hd__dlygate4sd3_1
Xhold428 _5920_/Q VGND VGND VPWR VPWR hold428/X sky130_fd_sc_hd__dlygate4sd3_1
X_3422_ _5639_/Q hold58/X _3961_/A VGND VGND VPWR VPWR _5537_/D sky130_fd_sc_hd__mux2_1
X_6141_ _6144_/CLK _6141_/D fanout331/X VGND VGND VPWR VPWR _6141_/Q sky130_fd_sc_hd__dfrtp_1
Xmax_cap169 _2831_/Y VGND VGND VPWR VPWR _2941_/B1 sky130_fd_sc_hd__clkbuf_1
X_3353_ _5362_/B _3353_/B _3353_/C VGND VGND VPWR VPWR _3353_/X sky130_fd_sc_hd__or3_1
X_6072_ _6113_/CLK _6072_/D fanout337/X VGND VGND VPWR VPWR _6072_/Q sky130_fd_sc_hd__dfrtp_1
X_3284_ _5427_/A _6030_/Q VGND VGND VPWR VPWR _3357_/C sky130_fd_sc_hd__xor2_1
XANTENNA__2828__A1 _5467_/Q VGND VGND VPWR VPWR sky130_fd_sc_hd__diode_2
X_5023_ hold372/X _5043_/A2 _5022_/X VGND VGND VPWR VPWR _5957_/D sky130_fd_sc_hd__a21o_1
XANTENNA__2828__B2 _4964_/A0 VGND VGND VPWR VPWR sky130_fd_sc_hd__diode_2
XFILLER_65_151 VGND VGND VPWR VPWR sky130_fd_sc_hd__fill_1
XTAP_TAPCELL_ROW_0_169 VGND VPWR sky130_fd_sc_hd__tapvpwrvgnd_1
XANTENNA__2754__A _6171_/Q VGND VGND VPWR VPWR sky130_fd_sc_hd__diode_2
X_5925_ _5963_/CLK _5925_/D fanout307/X VGND VGND VPWR VPWR _5925_/Q sky130_fd_sc_hd__dfrtp_1
X_5856_ _6026_/CLK _5856_/D fanout280/X VGND VGND VPWR VPWR _5856_/Q sky130_fd_sc_hd__dfrtp_1
XFILLER_34_593 VGND VGND VPWR VPWR sky130_fd_sc_hd__fill_2
X_4807_ _4964_/A0 hold292/X _4807_/S VGND VGND VPWR VPWR _5844_/D sky130_fd_sc_hd__mux2_1
XPHY_EDGE_ROW_3_Right_3 VGND VGND VPWR VPWR sky130_fd_sc_hd__decap_3
X_2999_ _5517_/Q _5487_/Q _5467_/Q _2824_/C _3150_/B _3150_/C VGND VGND VPWR VPWR
+ _2999_/X sky130_fd_sc_hd__mux4_1
X_5787_ _6032_/CLK _5787_/D fanout299/X VGND VGND VPWR VPWR _5787_/Q sky130_fd_sc_hd__dfrtp_1
X_4738_ _5799_/Q _4970_/A0 _4746_/S VGND VGND VPWR VPWR _4738_/X sky130_fd_sc_hd__mux2_1
XANTENNA_fanout123_X _5024_/B1 VGND VGND VPWR VPWR sky130_fd_sc_hd__diode_2
X_4669_ _5957_/Q _5765_/Q _4687_/S VGND VGND VPWR VPWR _4669_/X sky130_fd_sc_hd__mux2_1
XFILLER_0_125 VPWR VGND VPWR VGND sky130_ef_sc_hd__decap_12
XFILLER_76_405 VGND VGND VPWR VPWR sky130_fd_sc_hd__fill_1
XFILLER_0_169 VPWR VGND VPWR VGND sky130_ef_sc_hd__decap_12
XTAP_TAPCELL_ROW_27_522 VGND VPWR sky130_fd_sc_hd__tapvpwrvgnd_1
XTAP_TAPCELL_ROW_55_864 VGND VPWR sky130_fd_sc_hd__tapvpwrvgnd_1
XFILLER_13_711 VGND VGND VPWR VPWR sky130_fd_sc_hd__fill_2
XANTENNA__4992__B2 _4898_/X VGND VGND VPWR VPWR sky130_fd_sc_hd__diode_2
XFILLER_12_243 VGND VGND VPWR VPWR sky130_fd_sc_hd__fill_1
XFILLER_40_563 VGND VGND VPWR VPWR sky130_fd_sc_hd__fill_1
XFILLER_60_63 VGND VGND VPWR VPWR sky130_fd_sc_hd__fill_1
XTAP_TAPCELL_ROW_74_1107 VGND VPWR sky130_fd_sc_hd__tapvpwrvgnd_1
XANTENNA__3434__S _3434_/S VGND VGND VPWR VPWR sky130_fd_sc_hd__diode_2
XFILLER_67_405 VGND VGND VPWR VPWR sky130_fd_sc_hd__fill_1
XFILLER_79_287 VGND VGND VPWR VPWR sky130_fd_sc_hd__fill_1
XFILLER_67_427 VGND VGND VPWR VPWR sky130_fd_sc_hd__decap_3
XANTENNA__5940__RESET_B fanout306/X VGND VGND VPWR VPWR sky130_fd_sc_hd__diode_2
X_3971_ hold188/X hold92/X _5686_/Q VGND VGND VPWR VPWR _5617_/D sky130_fd_sc_hd__mux2_1
X_2922_ _5878_/Q _2928_/A2 _2927_/B1 _5890_/Q VGND VGND VPWR VPWR _2922_/X sky130_fd_sc_hd__a22o_1
X_5710_ _5723_/CLK _5710_/D fanout293/X VGND VGND VPWR VPWR _5710_/Q sky130_fd_sc_hd__dfrtp_1
XANTENNA__5096__S _5096_/S VGND VGND VPWR VPWR sky130_fd_sc_hd__diode_2
X_2853_ _5821_/Q _2921_/B1 _2797_/X VGND VGND VPWR VPWR _2856_/A sky130_fd_sc_hd__a21bo_1
X_5641_ _5645_/CLK _5641_/D VGND VGND VPWR VPWR _5641_/Q sky130_fd_sc_hd__dfxtp_1
X_2784_ _2864_/A _2871_/B _2871_/C VGND VGND VPWR VPWR _2784_/X sky130_fd_sc_hd__or3_2
X_5572_ _5811_/CLK _5572_/D fanout289/X VGND VGND VPWR VPWR _5572_/Q sky130_fd_sc_hd__dfrtp_1
X_4523_ _3639_/A _3647_/A _4522_/D _4522_/C VGND VGND VPWR VPWR _4524_/B sky130_fd_sc_hd__a31o_1
Xhold203 _6089_/Q VGND VGND VPWR VPWR hold203/X sky130_fd_sc_hd__dlygate4sd3_1
Xhold214 _6022_/Q VGND VGND VPWR VPWR hold214/X sky130_fd_sc_hd__dlygate4sd3_1
XPHY_EDGE_ROW_68_Left_149 VGND VGND VPWR VPWR sky130_fd_sc_hd__decap_3
Xhold225 _6091_/Q VGND VGND VPWR VPWR hold225/X sky130_fd_sc_hd__dlygate4sd3_1
Xhold247 _6093_/Q VGND VGND VPWR VPWR hold247/X sky130_fd_sc_hd__dlygate4sd3_1
Xhold236 _5995_/Q VGND VGND VPWR VPWR hold236/X sky130_fd_sc_hd__dlygate4sd3_1
Xhold258 _5880_/Q VGND VGND VPWR VPWR hold258/X sky130_fd_sc_hd__dlygate4sd3_1
Xhold269 _5872_/Q VGND VGND VPWR VPWR hold269/X sky130_fd_sc_hd__dlygate4sd3_1
X_4454_ _4479_/A _4479_/B VGND VGND VPWR VPWR _4454_/Y sky130_fd_sc_hd__nand2_1
XANTENNA__5160__A1 _5470_/Q VGND VGND VPWR VPWR sky130_fd_sc_hd__diode_2
X_3405_ _4967_/A0 _5522_/Q _3407_/S VGND VGND VPWR VPWR _5522_/D sky130_fd_sc_hd__mux2_1
X_4385_ _4408_/C _4385_/B VGND VGND VPWR VPWR _4385_/X sky130_fd_sc_hd__or2_1
X_6124_ _6161_/CLK _6124_/D fanout311/X VGND VGND VPWR VPWR _6124_/Q sky130_fd_sc_hd__dfrtp_1
X_3336_ _3336_/A _6025_/Q VGND VGND VPWR VPWR _3356_/D sky130_fd_sc_hd__nor2_1
X_6055_ _6061_/CLK _6055_/D fanout283/X VGND VGND VPWR VPWR _6055_/Q sky130_fd_sc_hd__dfrtp_1
XTAP_TAPCELL_ROW_5_239 VGND VPWR sky130_fd_sc_hd__tapvpwrvgnd_1
X_5006_ _4605_/X _5024_/A2 _5024_/B1 _4919_/X VGND VGND VPWR VPWR _5006_/X sky130_fd_sc_hd__a22o_1
X_3267_ _3930_/C _3267_/B _3928_/A VGND VGND VPWR VPWR _3268_/D sky130_fd_sc_hd__or3_1
XANTENNA_fanout285_A fanout286/X VGND VGND VPWR VPWR sky130_fd_sc_hd__diode_2
X_3198_ _5094_/A1 _5469_/Q _3203_/S VGND VGND VPWR VPWR _5469_/D sky130_fd_sc_hd__mux2_1
XFILLER_26_313 VGND VGND VPWR VPWR sky130_fd_sc_hd__fill_1
XPHY_EDGE_ROW_77_Left_158 VGND VGND VPWR VPWR sky130_fd_sc_hd__decap_3
XFILLER_38_184 VGND VGND VPWR VPWR sky130_fd_sc_hd__decap_6
XANTENNA__3226__A1 _5491_/Q VGND VGND VPWR VPWR sky130_fd_sc_hd__diode_2
XFILLER_54_699 VGND VGND VPWR VPWR sky130_fd_sc_hd__fill_1
XTAP_TAPCELL_ROW_52_834 VGND VPWR sky130_fd_sc_hd__tapvpwrvgnd_1
XANTENNA_fanout240_X _3623_/A VGND VGND VPWR VPWR sky130_fd_sc_hd__diode_2
X_5908_ _6032_/CLK _5908_/D fanout300/X VGND VGND VPWR VPWR _5908_/Q sky130_fd_sc_hd__dfrtp_1
X_5839_ _6094_/CLK _5839_/D fanout350/X VGND VGND VPWR VPWR _5839_/Q sky130_fd_sc_hd__dfrtp_1
XANTENNA__4726__A1 _4750_/A1 VGND VGND VPWR VPWR sky130_fd_sc_hd__diode_2
XTAP_TAPCELL_ROW_32_580 VGND VPWR sky130_fd_sc_hd__tapvpwrvgnd_1
XANTENNA__5151__A1 _5489_/Q VGND VGND VPWR VPWR sky130_fd_sc_hd__diode_2
XANTENNA__4662__B1 _4686_/B1 VGND VGND VPWR VPWR sky130_fd_sc_hd__diode_2
XFILLER_64_419 VGND VGND VPWR VPWR sky130_fd_sc_hd__fill_1
XFILLER_57_493 VGND VGND VPWR VPWR sky130_fd_sc_hd__decap_4
XFILLER_55_41 VGND VGND VPWR VPWR sky130_fd_sc_hd__fill_1
XFILLER_17_324 VPWR VGND VPWR VGND sky130_ef_sc_hd__decap_12
XANTENNA__5478__Q _5478_/Q VGND VGND VPWR VPWR sky130_fd_sc_hd__diode_2
XFILLER_17_357 VPWR VGND VPWR VGND sky130_ef_sc_hd__decap_12
XANTENNA__5201__C _6174_/Q VGND VGND VPWR VPWR sky130_fd_sc_hd__diode_2
XFILLER_32_349 VGND VGND VPWR VPWR sky130_fd_sc_hd__fill_1
XANTENNA__3768__A2 _3783_/A VGND VGND VPWR VPWR sky130_fd_sc_hd__diode_2
XTAP_TAPCELL_ROW_80_1177 VGND VPWR sky130_fd_sc_hd__tapvpwrvgnd_1
XANTENNA__3429__S _3434_/S VGND VGND VPWR VPWR sky130_fd_sc_hd__diode_2
XTAP_TAPCELL_ROW_80_1188 VGND VPWR sky130_fd_sc_hd__tapvpwrvgnd_1
XFILLER_9_589 VGND VGND VPWR VPWR sky130_fd_sc_hd__decap_3
X_4170_ _5901_/Q _4867_/A VGND VGND VPWR VPWR _4170_/Y sky130_fd_sc_hd__nor2_2
X_3121_ _5920_/Q _2978_/Y _3119_/X _3120_/X _2984_/Y VGND VGND VPWR VPWR _3121_/X
+ sky130_fd_sc_hd__o221a_1
XFILLER_67_235 VGND VGND VPWR VPWR sky130_fd_sc_hd__fill_1
XTAP_TAPCELL_ROW_2_209 VGND VPWR sky130_fd_sc_hd__tapvpwrvgnd_1
XFILLER_67_279 VGND VGND VPWR VPWR sky130_fd_sc_hd__fill_1
X_3052_ _5675_/Q _2766_/Y _3048_/Y VGND VGND VPWR VPWR _3052_/Y sky130_fd_sc_hd__o21ai_1
XFILLER_63_430 VGND VGND VPWR VPWR sky130_fd_sc_hd__fill_1
X_3954_ _3954_/A _3954_/B VGND VGND VPWR VPWR _5609_/D sky130_fd_sc_hd__xnor2_1
XFILLER_23_349 VGND VGND VPWR VPWR sky130_fd_sc_hd__decap_3
X_2905_ _2725_/Y _2939_/B _2902_/X _2904_/X VGND VGND VPWR VPWR _2905_/X sky130_fd_sc_hd__a2bb2o_1
X_3885_ _3896_/B _3884_/Y _3916_/S _4118_/B VGND VGND VPWR VPWR _3885_/X sky130_fd_sc_hd__a2bb2o_1
X_2836_ _5768_/Q _5067_/B VGND VGND VPWR VPWR _5140_/C sky130_fd_sc_hd__nand2_1
X_5624_ _5690_/CLK _5624_/D fanout317/X VGND VGND VPWR VPWR _5624_/Q sky130_fd_sc_hd__dfstp_1
X_2767_ _5715_/Q VGND VGND VPWR VPWR _2767_/Y sky130_fd_sc_hd__inv_2
XANTENNA__4184__A2 _4167_/Y VGND VGND VPWR VPWR sky130_fd_sc_hd__diode_2
X_5555_ _5697_/CLK _5555_/D VGND VGND VPWR VPWR hold86/A sky130_fd_sc_hd__dfxtp_1
X_5486_ _5645_/CLK _5486_/D VGND VGND VPWR VPWR hold50/A sky130_fd_sc_hd__dfxtp_1
X_4506_ _4482_/A _4482_/B _4491_/Y _4505_/X VGND VGND VPWR VPWR _4507_/B sky130_fd_sc_hd__a31o_1
XANTENNA__3931__A2 _3240_/B VGND VGND VPWR VPWR sky130_fd_sc_hd__diode_2
XANTENNA_fanout200_A _6113_/Q VGND VGND VPWR VPWR sky130_fd_sc_hd__diode_2
XANTENNA__3582__B _3647_/A VGND VGND VPWR VPWR sky130_fd_sc_hd__diode_2
X_4437_ _4357_/X _4436_/X _4427_/Y VGND VGND VPWR VPWR _5742_/D sky130_fd_sc_hd__o21ai_1
XANTENNA_input5_A uio_in[6] VGND VGND VPWR VPWR sky130_fd_sc_hd__diode_2
XANTENNA__4892__A0 _5797_/Q VGND VGND VPWR VPWR sky130_fd_sc_hd__diode_2
X_6107_ _6107_/CLK _6107_/D fanout273/X VGND VGND VPWR VPWR _6107_/Q sky130_fd_sc_hd__dfrtp_1
X_4368_ _6109_/Q _5736_/Q _5737_/Q VGND VGND VPWR VPWR _4384_/B sky130_fd_sc_hd__and3_1
X_4299_ _5714_/Q _4265_/X _4298_/X _4252_/X VGND VGND VPWR VPWR _4299_/X sky130_fd_sc_hd__a22o_1
X_3319_ _3905_/A _5990_/Q VGND VGND VPWR VPWR _3345_/B sky130_fd_sc_hd__and2b_1
XANTENNA_fanout190_X _5412_/A VGND VGND VPWR VPWR sky130_fd_sc_hd__diode_2
XANTENNA__4644__B1 _4684_/A2 VGND VGND VPWR VPWR sky130_fd_sc_hd__diode_2
X_6038_ _6106_/CLK _6038_/D fanout274/X VGND VGND VPWR VPWR _6038_/Q sky130_fd_sc_hd__dfrtp_1
XFILLER_27_644 VGND VGND VPWR VPWR sky130_fd_sc_hd__fill_1
XFILLER_27_677 VGND VGND VPWR VPWR sky130_fd_sc_hd__decap_6
XTAP_TAPCELL_ROW_65_992 VGND VPWR sky130_fd_sc_hd__tapvpwrvgnd_1
XFILLER_25_77 VGND VGND VPWR VPWR sky130_fd_sc_hd__fill_1
XFILLER_22_360 VGND VGND VPWR VPWR sky130_fd_sc_hd__decap_4
XFILLER_6_504 VGND VGND VPWR VPWR sky130_fd_sc_hd__decap_4
XANTENNA__3383__B1 _4544_/A VGND VGND VPWR VPWR sky130_fd_sc_hd__diode_2
XANTENNA__5761__Q _5761_/Q VGND VGND VPWR VPWR sky130_fd_sc_hd__diode_2
XFILLER_77_522 VGND VGND VPWR VPWR sky130_fd_sc_hd__fill_1
XANTENNA__3686__A1 _4399_/A VGND VGND VPWR VPWR sky130_fd_sc_hd__diode_2
XFILLER_1_275 VGND VGND VPWR VPWR sky130_fd_sc_hd__decap_4
XFILLER_2_15 VPWR VGND VPWR VGND sky130_ef_sc_hd__decap_12
XANTENNA__4808__S _4810_/S VGND VGND VPWR VPWR sky130_fd_sc_hd__diode_2
XTAP_TAPCELL_ROW_69_1039 VGND VPWR sky130_fd_sc_hd__tapvpwrvgnd_1
XANTENNA__4635__B1 _4747_/B1 VGND VGND VPWR VPWR sky130_fd_sc_hd__diode_2
XFILLER_17_121 VGND VGND VPWR VPWR sky130_fd_sc_hd__decap_4
XFILLER_17_165 VGND VGND VPWR VPWR sky130_fd_sc_hd__decap_3
XFILLER_17_187 VPWR VGND VPWR VGND sky130_ef_sc_hd__decap_12
XFILLER_18_688 VGND VGND VPWR VPWR sky130_fd_sc_hd__fill_1
XFILLER_45_485 VGND VGND VPWR VPWR sky130_fd_sc_hd__fill_2
XTAP_TAPCELL_ROW_15_366 VGND VPWR sky130_fd_sc_hd__tapvpwrvgnd_1
XFILLER_32_168 VGND VGND VPWR VPWR sky130_fd_sc_hd__fill_1
X_3670_ _4873_/A _4873_/B _3710_/B VGND VGND VPWR VPWR _3671_/D sky130_fd_sc_hd__or3_1
XFILLER_56_3 VPWR VGND VPWR VGND sky130_ef_sc_hd__decap_12
X_5340_ _5329_/X _5331_/X _5338_/Y _5327_/C VGND VGND VPWR VPWR _5340_/Y sky130_fd_sc_hd__o31ai_1
X_5271_ hold426/X _5341_/B2 fanout9/X _5270_/X VGND VGND VPWR VPWR _6148_/D sky130_fd_sc_hd__a22o_1
XANTENNA__5115__A1 _4444_/B VGND VGND VPWR VPWR sky130_fd_sc_hd__diode_2
X_4222_ _5774_/Q _4169_/X _4221_/X _3192_/B VGND VGND VPWR VPWR _4227_/A sky130_fd_sc_hd__o211a_1
XANTENNA__3677__A1 _2744_/A VGND VGND VPWR VPWR sky130_fd_sc_hd__diode_2
X_4153_ _4152_/A _4152_/B _5459_/B VGND VGND VPWR VPWR _4155_/B sky130_fd_sc_hd__o21a_1
XFILLER_68_544 VGND VGND VPWR VPWR sky130_fd_sc_hd__fill_1
XANTENNA__4626__A0 _5467_/Q VGND VGND VPWR VPWR sky130_fd_sc_hd__diode_2
X_3104_ _3104_/A _3104_/B VGND VGND VPWR VPWR _3104_/Y sky130_fd_sc_hd__nor2_1
X_4084_ _5582_/Q hold90/X _4091_/S VGND VGND VPWR VPWR _5691_/D sky130_fd_sc_hd__mux2_1
X_3035_ _3033_/X _3034_/X _5590_/Q VGND VGND VPWR VPWR _3035_/X sky130_fd_sc_hd__mux2_1
XFILLER_36_485 VGND VGND VPWR VPWR sky130_fd_sc_hd__fill_2
X_4986_ _4202_/X _5026_/A2 _5026_/B1 _4889_/X VGND VGND VPWR VPWR _4986_/X sky130_fd_sc_hd__a22o_1
XTAP_TAPCELL_ROW_62_951 VGND VPWR sky130_fd_sc_hd__tapvpwrvgnd_1
XANTENNA__3577__B _3651_/B VGND VGND VPWR VPWR sky130_fd_sc_hd__diode_2
XANTENNA_fanout248_A _3651_/B VGND VGND VPWR VPWR sky130_fd_sc_hd__diode_2
X_3937_ hold454/X _3544_/X _3940_/S VGND VGND VPWR VPWR _5595_/D sky130_fd_sc_hd__mux2_1
X_3868_ _5811_/Q _5512_/Q _3904_/S VGND VGND VPWR VPWR _3868_/X sky130_fd_sc_hd__mux2_1
X_3799_ _5571_/Q _3811_/C VGND VGND VPWR VPWR _3799_/Y sky130_fd_sc_hd__nor2_1
X_2819_ _6063_/Q _5867_/Q _5991_/Q _5816_/Q _6114_/Q _6115_/Q VGND VGND VPWR VPWR
+ _2819_/X sky130_fd_sc_hd__mux4_1
XANTENNA__6061__RESET_B fanout283/X VGND VGND VPWR VPWR sky130_fd_sc_hd__diode_2
X_5607_ _5635_/CLK _5607_/D fanout315/X VGND VGND VPWR VPWR _5607_/Q sky130_fd_sc_hd__dfrtp_1
X_5538_ _6149_/CLK _5538_/D VGND VGND VPWR VPWR hold72/A sky130_fd_sc_hd__dfxtp_1
XANTENNA__4825__A_N _4873_/A VGND VGND VPWR VPWR sky130_fd_sc_hd__diode_2
XANTENNA__5106__A1 _6171_/Q VGND VGND VPWR VPWR sky130_fd_sc_hd__diode_2
X_5469_ _6021_/CLK _5469_/D fanout332/X VGND VGND VPWR VPWR _5469_/Q sky130_fd_sc_hd__dfrtp_4
Xfanout332 fanout334/X VGND VGND VPWR VPWR fanout332/X sky130_fd_sc_hd__clkbuf_4
Xfanout310 fanout324/X VGND VGND VPWR VPWR fanout310/X sky130_fd_sc_hd__clkbuf_4
Xfanout321 fanout323/X VGND VGND VPWR VPWR fanout321/X sky130_fd_sc_hd__clkbuf_4
Xfanout343 fanout351/X VGND VGND VPWR VPWR fanout343/X sky130_fd_sc_hd__clkbuf_2
XFILLER_74_558 VGND VGND VPWR VPWR sky130_fd_sc_hd__fill_1
XANTENNA__2891__A2 _2786_/X VGND VGND VPWR VPWR sky130_fd_sc_hd__diode_2
XANTENNA__4617__B1 _4616_/X VGND VGND VPWR VPWR sky130_fd_sc_hd__diode_2
XFILLER_46_249 VGND VGND VPWR VPWR sky130_fd_sc_hd__fill_1
XFILLER_61_208 VGND VGND VPWR VPWR sky130_fd_sc_hd__decap_3
XANTENNA__3840__A1 _3623_/A VGND VGND VPWR VPWR sky130_fd_sc_hd__diode_2
XFILLER_27_496 VGND VGND VPWR VPWR sky130_fd_sc_hd__decap_6
XFILLER_30_606 VGND VGND VPWR VPWR sky130_fd_sc_hd__fill_1
XFILLER_42_466 VGND VGND VPWR VPWR sky130_fd_sc_hd__decap_3
XTAP_TAPCELL_ROW_12_336 VGND VPWR sky130_fd_sc_hd__tapvpwrvgnd_1
XTAP_TAPCELL_ROW_12_325 VGND VPWR sky130_fd_sc_hd__tapvpwrvgnd_1
XANTENNA__6149__RESET_B fanout310/X VGND VGND VPWR VPWR sky130_fd_sc_hd__diode_2
XTAP_TAPCELL_ROW_40_678 VGND VPWR sky130_fd_sc_hd__tapvpwrvgnd_1
XANTENNA__5491__Q _5491_/Q VGND VGND VPWR VPWR sky130_fd_sc_hd__diode_2
XANTENNA__4886__X _4886_/X VGND VGND VPWR VPWR sky130_fd_sc_hd__diode_2
XANTENNA__4856__A0 _5474_/Q VGND VGND VPWR VPWR sky130_fd_sc_hd__diode_2
XANTENNA__3123__A3 _2843_/B VGND VGND VPWR VPWR sky130_fd_sc_hd__diode_2
XANTENNA__3442__S _3442_/S VGND VGND VPWR VPWR sky130_fd_sc_hd__diode_2
XFILLER_77_83 VGND VGND VPWR VPWR sky130_fd_sc_hd__fill_2
XFILLER_65_503 VGND VGND VPWR VPWR sky130_fd_sc_hd__fill_1
XANTENNA__2882__A2 _2917_/A2 VGND VGND VPWR VPWR sky130_fd_sc_hd__diode_2
XTAP_TAPCELL_ROW_48_778 VGND VPWR sky130_fd_sc_hd__tapvpwrvgnd_1
X_4840_ _5524_/Q hold298/X _4864_/S VGND VGND VPWR VPWR _5874_/D sky130_fd_sc_hd__mux2_1
XFILLER_60_230 VGND VGND VPWR VPWR sky130_fd_sc_hd__fill_1
XFILLER_60_241 VGND VGND VPWR VPWR sky130_fd_sc_hd__fill_1
XFILLER_20_105 VGND VGND VPWR VPWR sky130_fd_sc_hd__decap_6
XFILLER_21_639 VPWR VGND VPWR VGND sky130_ef_sc_hd__decap_12
X_4771_ hold159/X _3841_/X _4776_/S VGND VGND VPWR VPWR _5809_/D sky130_fd_sc_hd__mux2_1
X_3722_ _5861_/Q _3648_/A _3720_/Y _3721_/Y _3719_/X VGND VGND VPWR VPWR _3722_/X
+ sky130_fd_sc_hd__a41o_1
XFILLER_9_150 VGND VGND VPWR VPWR sky130_fd_sc_hd__fill_1
XFILLER_9_183 VGND VGND VPWR VPWR sky130_fd_sc_hd__decap_4
X_3653_ _3698_/B _3653_/B _3698_/C _3698_/D VGND VGND VPWR VPWR _3659_/C sky130_fd_sc_hd__or4_1
X_3584_ _3674_/B _3584_/B _3584_/C _3709_/A VGND VGND VPWR VPWR _3585_/D sky130_fd_sc_hd__or4_1
X_5323_ _6157_/Q _5337_/B VGND VGND VPWR VPWR _5326_/A sky130_fd_sc_hd__xor2_1
XANTENNA__4847__A0 _5493_/Q VGND VGND VPWR VPWR sky130_fd_sc_hd__diode_2
X_5254_ _6146_/Q _5285_/B VGND VGND VPWR VPWR _5257_/A sky130_fd_sc_hd__and2_1
X_4205_ _5906_/Q _5763_/Q _4232_/S VGND VGND VPWR VPWR _4205_/X sky130_fd_sc_hd__mux2_1
X_5185_ hold345/X _4517_/A _5185_/S VGND VGND VPWR VPWR _6107_/D sky130_fd_sc_hd__mux2_1
X_4136_ _4315_/A _4329_/A VGND VGND VPWR VPWR _4136_/X sky130_fd_sc_hd__and2_1
XFILLER_68_363 VGND VGND VPWR VPWR sky130_fd_sc_hd__fill_1
XANTENNA__2873__A2 _2886_/B VGND VGND VPWR VPWR sky130_fd_sc_hd__diode_2
XFILLER_28_249 VGND VGND VPWR VPWR sky130_fd_sc_hd__decap_3
X_4067_ hold83/X _3975_/Y _4065_/X _4066_/X VGND VGND VPWR VPWR _5665_/D sky130_fd_sc_hd__a22o_1
XANTENNA__4075__B2 _4542_/A VGND VGND VPWR VPWR sky130_fd_sc_hd__diode_2
X_3018_ _5676_/Q _5597_/Q _2958_/X _5606_/Q VGND VGND VPWR VPWR _3018_/X sky130_fd_sc_hd__a22o_1
XFILLER_24_400 VPWR VGND VPWR VGND sky130_ef_sc_hd__decap_12
XANTENNA__3588__A _4873_/A VGND VGND VPWR VPWR sky130_fd_sc_hd__diode_2
XANTENNA__5024__B1 _5024_/B1 VGND VGND VPWR VPWR sky130_fd_sc_hd__diode_2
X_4969_ _5932_/Q _4975_/A2 _4968_/X VGND VGND VPWR VPWR _5932_/D sky130_fd_sc_hd__a21o_1
XANTENNA__3889__A1 _5447_/A VGND VGND VPWR VPWR sky130_fd_sc_hd__diode_2
XFILLER_79_617 VGND VGND VPWR VPWR sky130_fd_sc_hd__fill_1
XANTENNA__4838__A0 _5522_/Q VGND VGND VPWR VPWR sky130_fd_sc_hd__diode_2
Xfanout140 _5026_/A2 VGND VGND VPWR VPWR _5038_/A2 sky130_fd_sc_hd__clkbuf_4
Xfanout173 _2926_/B1 VGND VGND VPWR VPWR _2921_/B1 sky130_fd_sc_hd__clkbuf_4
Xfanout162 _2979_/Y VGND VGND VPWR VPWR _4232_/S sky130_fd_sc_hd__clkbuf_4
XFILLER_47_503 VGND VGND VPWR VPWR sky130_fd_sc_hd__fill_1
Xfanout151 _4761_/A2 VGND VGND VPWR VPWR _5174_/A2 sky130_fd_sc_hd__buf_2
Xfanout184 _2782_/Y VGND VGND VPWR VPWR _2783_/B sky130_fd_sc_hd__clkbuf_4
XFILLER_47_525 VGND VGND VPWR VPWR sky130_fd_sc_hd__fill_1
Xfanout195 _5369_/A VGND VGND VPWR VPWR _3394_/S sky130_fd_sc_hd__clkbuf_4
XFILLER_47_569 VGND VGND VPWR VPWR sky130_fd_sc_hd__fill_1
XFILLER_47_75 VGND VGND VPWR VPWR sky130_fd_sc_hd__fill_2
XTAP_TAPCELL_ROW_66_1009 VGND VPWR sky130_fd_sc_hd__tapvpwrvgnd_1
XTAP_TAPCELL_ROW_45_737 VGND VPWR sky130_fd_sc_hd__tapvpwrvgnd_1
XFILLER_15_444 VGND VGND VPWR VPWR sky130_fd_sc_hd__fill_1
XTAP_TAPCELL_ROW_45_748 VGND VPWR sky130_fd_sc_hd__tapvpwrvgnd_1
XANTENNA__2833__C _5521_/Q VGND VGND VPWR VPWR sky130_fd_sc_hd__diode_2
XANTENNA__4369__A2 _5736_/Q VGND VGND VPWR VPWR sky130_fd_sc_hd__diode_2
XTAP_TAPCELL_ROW_25_494 VGND VPWR sky130_fd_sc_hd__tapvpwrvgnd_1
XFILLER_8_25 VGND VGND VPWR VPWR sky130_fd_sc_hd__decap_3
XTAP_TAPCELL_ROW_77_1138 VGND VPWR sky130_fd_sc_hd__tapvpwrvgnd_1
XANTENNA__5965__RESET_B fanout303/X VGND VGND VPWR VPWR sky130_fd_sc_hd__diode_2
XANTENNA__3437__S _3442_/S VGND VGND VPWR VPWR sky130_fd_sc_hd__diode_2
XFILLER_7_687 VPWR VGND VPWR VGND sky130_ef_sc_hd__decap_12
XANTENNA_clkbuf_leaf_23_clk_A clkload2/A VGND VGND VPWR VPWR sky130_fd_sc_hd__diode_2
XANTENNA__2855__A2 _2910_/B VGND VGND VPWR VPWR sky130_fd_sc_hd__diode_2
XFILLER_19_3 VPWR VGND VPWR VGND sky130_ef_sc_hd__decap_12
XANTENNA__3275__A_N _5377_/A VGND VGND VPWR VPWR sky130_fd_sc_hd__diode_2
XFILLER_80_325 VGND VGND VPWR VPWR sky130_fd_sc_hd__fill_1
X_5941_ _5965_/CLK _5941_/D fanout300/X VGND VGND VPWR VPWR _5941_/Q sky130_fd_sc_hd__dfrtp_1
XANTENNA_clkbuf_leaf_38_clk_A clkload1/A VGND VGND VPWR VPWR sky130_fd_sc_hd__diode_2
XANTENNA__3804__A1 _4427_/A VGND VGND VPWR VPWR sky130_fd_sc_hd__diode_2
XANTENNA__5006__B1 _5024_/B1 VGND VGND VPWR VPWR sky130_fd_sc_hd__diode_2
X_5872_ _6088_/CLK _5872_/D fanout340/X VGND VGND VPWR VPWR _5872_/Q sky130_fd_sc_hd__dfrtp_1
XFILLER_33_263 VGND VGND VPWR VPWR sky130_fd_sc_hd__fill_1
X_4823_ _4517_/A _4823_/A2 _4824_/B1 hold133/X VGND VGND VPWR VPWR _5859_/D sky130_fd_sc_hd__a22o_1
XANTENNA__3032__A2 _2965_/X VGND VGND VPWR VPWR sky130_fd_sc_hd__diode_2
X_4754_ _5793_/Q _5174_/A2 _4561_/B _3549_/Y VGND VGND VPWR VPWR _5793_/D sky130_fd_sc_hd__a22o_1
X_3705_ _3705_/A _5230_/A VGND VGND VPWR VPWR _5198_/B sky130_fd_sc_hd__and2_1
X_4685_ _5959_/Q _5767_/Q _4687_/S VGND VGND VPWR VPWR _4685_/X sky130_fd_sc_hd__mux2_1
X_3636_ _4530_/A _6045_/Q VGND VGND VPWR VPWR _3720_/B sky130_fd_sc_hd__nor2_1
X_3567_ _3930_/C _3567_/B VGND VGND VPWR VPWR _5206_/B sky130_fd_sc_hd__nand2_1
X_5306_ _6154_/Q _5343_/B VGND VGND VPWR VPWR _5307_/B sky130_fd_sc_hd__xnor2_1
XANTENNA__3590__B _4399_/A VGND VGND VPWR VPWR sky130_fd_sc_hd__diode_2
XFILLER_0_329 VGND VGND VPWR VPWR sky130_fd_sc_hd__decap_3
X_5237_ _5237_/A _5237_/B VGND VGND VPWR VPWR _5237_/X sky130_fd_sc_hd__and2_1
X_3498_ _3530_/A _3550_/A VGND VGND VPWR VPWR _3538_/A sky130_fd_sc_hd__nand2_4
X_5168_ hold178/X _5728_/Q _5172_/S VGND VGND VPWR VPWR _6090_/D sky130_fd_sc_hd__mux2_1
XFILLER_56_300 VGND VGND VPWR VPWR sky130_fd_sc_hd__fill_1
X_5099_ hold214/X _5478_/Q _5099_/S VGND VGND VPWR VPWR _6022_/D sky130_fd_sc_hd__mux2_1
XANTENNA_fanout270_X _4967_/A0 VGND VGND VPWR VPWR sky130_fd_sc_hd__diode_2
X_4119_ _4119_/A _4119_/B _4119_/C _4119_/D VGND VGND VPWR VPWR _4130_/B sky130_fd_sc_hd__or4_1
XANTENNA__2934__B _2934_/B VGND VGND VPWR VPWR sky130_fd_sc_hd__diode_2
XTAP_TAPCELL_ROW_42_707 VGND VPWR sky130_fd_sc_hd__tapvpwrvgnd_1
XANTENNA__4220__A1 _5765_/Q VGND VGND VPWR VPWR sky130_fd_sc_hd__diode_2
XTAP_TAPCELL_ROW_22_453 VGND VPWR sky130_fd_sc_hd__tapvpwrvgnd_1
XANTENNA__4523__A2 _3647_/A VGND VGND VPWR VPWR sky130_fd_sc_hd__diode_2
XANTENNA__2949__X _3426_/D VGND VGND VPWR VPWR sky130_fd_sc_hd__diode_2
Xtt_um_bfcpu_357 VGND VGND VPWR VPWR tt_um_bfcpu_357/HI uio_out[2] sky130_fd_sc_hd__conb_1
Xtt_um_bfcpu_368 VGND VGND VPWR VPWR tt_um_bfcpu_368/HI uo_out[6] sky130_fd_sc_hd__conb_1
XFILLER_3_189 VGND VGND VPWR VPWR sky130_fd_sc_hd__decap_4
XTAP_TAPCELL_ROW_72_1079 VGND VPWR sky130_fd_sc_hd__tapvpwrvgnd_1
XFILLER_59_171 VGND VGND VPWR VPWR sky130_fd_sc_hd__fill_1
XFILLER_58_85 VGND VGND VPWR VPWR sky130_fd_sc_hd__decap_6
Xhold7 hold7/A VGND VGND VPWR VPWR hold7/X sky130_fd_sc_hd__dlygate4sd3_1
XFILLER_74_141 VGND VGND VPWR VPWR sky130_fd_sc_hd__decap_8
XANTENNA__2844__B _5472_/Q VGND VGND VPWR VPWR sky130_fd_sc_hd__diode_2
XFILLER_62_369 VPWR VGND VPWR VGND sky130_ef_sc_hd__decap_12
XANTENNA__4211__A1 _5764_/Q VGND VGND VPWR VPWR sky130_fd_sc_hd__diode_2
Xhold407 _5921_/Q VGND VGND VPWR VPWR hold407/X sky130_fd_sc_hd__dlygate4sd3_1
Xhold418 _5654_/Q VGND VGND VPWR VPWR hold418/X sky130_fd_sc_hd__dlygate4sd3_1
X_4470_ _3706_/X _4466_/X _4469_/Y _3479_/X VGND VGND VPWR VPWR _4470_/X sky130_fd_sc_hd__o22a_1
Xmax_cap137 _3204_/S VGND VGND VPWR VPWR _3207_/S sky130_fd_sc_hd__clkbuf_2
X_3421_ _5638_/Q hold47/X _3961_/A VGND VGND VPWR VPWR _5536_/D sky130_fd_sc_hd__mux2_1
Xhold429 _5945_/Q VGND VGND VPWR VPWR hold429/X sky130_fd_sc_hd__dlygate4sd3_1
X_6140_ _6144_/CLK _6140_/D fanout329/X VGND VGND VPWR VPWR _6140_/Q sky130_fd_sc_hd__dfrtp_1
X_3352_ _3335_/X _3341_/X _3351_/X VGND VGND VPWR VPWR _3353_/C sky130_fd_sc_hd__o21ai_1
X_6071_ _6091_/CLK _6071_/D fanout347/X VGND VGND VPWR VPWR _6071_/Q sky130_fd_sc_hd__dfrtp_1
X_3283_ _6167_/Q _6025_/Q VGND VGND VPWR VPWR _3295_/B sky130_fd_sc_hd__xor2_1
X_5022_ _4669_/X _5038_/A2 _5038_/B1 _4943_/X VGND VGND VPWR VPWR _5022_/X sky130_fd_sc_hd__a22o_1
XFILLER_80_100 VGND VGND VPWR VPWR sky130_fd_sc_hd__decap_3
XFILLER_53_314 VGND VGND VPWR VPWR sky130_fd_sc_hd__fill_1
XFILLER_80_144 VGND VGND VPWR VPWR sky130_fd_sc_hd__fill_1
X_5924_ _6097_/CLK _5924_/D fanout302/X VGND VGND VPWR VPWR _5924_/Q sky130_fd_sc_hd__dfrtp_1
XFILLER_0_81 VGND VGND VPWR VPWR sky130_fd_sc_hd__decap_3
XFILLER_22_701 VPWR VGND VPWR VGND sky130_ef_sc_hd__decap_12
X_5855_ _6026_/CLK _5855_/D fanout279/X VGND VGND VPWR VPWR _5855_/Q sky130_fd_sc_hd__dfrtp_1
X_4806_ _2934_/B hold257/X _4810_/S VGND VGND VPWR VPWR _5843_/D sky130_fd_sc_hd__mux2_1
XANTENNA__4202__A1 _5763_/Q VGND VGND VPWR VPWR sky130_fd_sc_hd__diode_2
X_2998_ _6095_/Q _3150_/C VGND VGND VPWR VPWR _4879_/B sky130_fd_sc_hd__nor2_2
X_5786_ _6050_/CLK _5786_/D fanout299/X VGND VGND VPWR VPWR _5786_/Q sky130_fd_sc_hd__dfrtp_1
X_4737_ hold194/X _4737_/A2 _4736_/X VGND VGND VPWR VPWR _5790_/D sky130_fd_sc_hd__o21a_1
X_4668_ _5957_/Q _4748_/A2 _4243_/S _4667_/X VGND VGND VPWR VPWR _4668_/X sky130_fd_sc_hd__a211o_1
X_3619_ _4428_/A _5970_/Q VGND VGND VPWR VPWR _3620_/C sky130_fd_sc_hd__nand2_1
X_4599_ _5915_/Q _5764_/Q _4615_/S VGND VGND VPWR VPWR _4599_/X sky130_fd_sc_hd__mux2_1
XFILLER_0_137 VGND VGND VPWR VPWR sky130_fd_sc_hd__decap_3
XFILLER_56_174 VGND VGND VPWR VPWR sky130_fd_sc_hd__decap_3
XFILLER_72_645 VGND VGND VPWR VPWR sky130_fd_sc_hd__fill_1
XFILLER_56_185 VGND VGND VPWR VPWR sky130_fd_sc_hd__decap_8
XTAP_TAPCELL_ROW_27_512 VGND VPWR sky130_fd_sc_hd__tapvpwrvgnd_1
XTAP_TAPCELL_ROW_27_523 VGND VPWR sky130_fd_sc_hd__tapvpwrvgnd_1
XTAP_TAPCELL_ROW_55_865 VGND VPWR sky130_fd_sc_hd__tapvpwrvgnd_1
XFILLER_9_705 VGND VGND VPWR VPWR sky130_fd_sc_hd__decap_8
XANTENNA__5764__Q _5764_/Q VGND VGND VPWR VPWR sky130_fd_sc_hd__diode_2
XANTENNA__4878__Y _4878_/Y VGND VGND VPWR VPWR sky130_fd_sc_hd__diode_2
XTAP_TAPCELL_ROW_74_1108 VGND VPWR sky130_fd_sc_hd__tapvpwrvgnd_1
XFILLER_4_421 VPWR VGND VPWR VGND sky130_ef_sc_hd__decap_12
XFILLER_69_51 VGND VGND VPWR VPWR sky130_fd_sc_hd__decap_4
XANTENNA__4400__A _4404_/A VGND VGND VPWR VPWR sky130_fd_sc_hd__diode_2
XTAP_TAPCELL_ROW_7_270 VGND VPWR sky130_fd_sc_hd__tapvpwrvgnd_1
XPHY_EDGE_ROW_13_Right_13 VGND VGND VPWR VPWR sky130_fd_sc_hd__decap_3
X_3970_ _5686_/Q hold92/A VGND VGND VPWR VPWR _3970_/X sky130_fd_sc_hd__and2_1
X_2921_ _5894_/Q _2921_/A2 _2921_/B1 _5874_/Q _2920_/X VGND VGND VPWR VPWR _2921_/X
+ sky130_fd_sc_hd__a221o_1
XANTENNA__4983__A2 _5043_/A2 VGND VGND VPWR VPWR sky130_fd_sc_hd__diode_2
X_2852_ _5845_/Q _2886_/B _2918_/B1 _5837_/Q VGND VGND VPWR VPWR _2852_/X sky130_fd_sc_hd__a22o_1
X_5640_ _6149_/CLK _5640_/D VGND VGND VPWR VPWR _5640_/Q sky130_fd_sc_hd__dfxtp_1
X_2783_ _2864_/A _2783_/B VGND VGND VPWR VPWR _2783_/X sky130_fd_sc_hd__and2b_2
X_5571_ _5707_/CLK _5571_/D fanout289/X VGND VGND VPWR VPWR _5571_/Q sky130_fd_sc_hd__dfrtp_2
XPHY_EDGE_ROW_22_Right_22 VGND VGND VPWR VPWR sky130_fd_sc_hd__decap_3
X_4522_ _4522_/A _4522_/B _4522_/C _4522_/D VGND VGND VPWR VPWR _4536_/B sky130_fd_sc_hd__and4_1
Xhold215 _5785_/Q VGND VGND VPWR VPWR hold215/X sky130_fd_sc_hd__dlygate4sd3_1
Xhold226 _5836_/Q VGND VGND VPWR VPWR hold226/X sky130_fd_sc_hd__dlygate4sd3_1
Xhold204 _5997_/Q VGND VGND VPWR VPWR hold204/X sky130_fd_sc_hd__dlygate4sd3_1
X_4453_ _4440_/B _4442_/B _4440_/A VGND VGND VPWR VPWR _4479_/B sky130_fd_sc_hd__o21bai_1
Xhold259 _5891_/Q VGND VGND VPWR VPWR hold259/X sky130_fd_sc_hd__dlygate4sd3_1
X_3404_ _4964_/A0 _5521_/Q _3407_/S VGND VGND VPWR VPWR _5521_/D sky130_fd_sc_hd__mux2_1
Xhold237 _6016_/Q VGND VGND VPWR VPWR hold237/X sky130_fd_sc_hd__dlygate4sd3_1
Xhold248 _6059_/Q VGND VGND VPWR VPWR hold248/X sky130_fd_sc_hd__dlygate4sd3_1
XANTENNA__5406__A _5406_/A VGND VGND VPWR VPWR sky130_fd_sc_hd__diode_2
X_4384_ _5738_/Q _4384_/B VGND VGND VPWR VPWR _4385_/B sky130_fd_sc_hd__nor2_1
X_6123_ _6161_/CLK _6123_/D fanout311/X VGND VGND VPWR VPWR _6123_/Q sky130_fd_sc_hd__dfrtp_1
X_3335_ _3357_/A _3335_/B _3359_/A _3354_/B VGND VGND VPWR VPWR _3335_/X sky130_fd_sc_hd__or4_1
X_6054_ _6159_/CLK _6054_/D fanout283/X VGND VGND VPWR VPWR _6054_/Q sky130_fd_sc_hd__dfrtp_1
X_3266_ _3930_/C _3928_/A VGND VGND VPWR VPWR _5204_/B sky130_fd_sc_hd__nor2_1
XPHY_EDGE_ROW_31_Right_31 VGND VGND VPWR VPWR sky130_fd_sc_hd__decap_3
X_5005_ hold424/X _5027_/A2 _5004_/X VGND VGND VPWR VPWR _5948_/D sky130_fd_sc_hd__a21o_1
X_3197_ _2843_/B _5468_/Q _3203_/S VGND VGND VPWR VPWR _5468_/D sky130_fd_sc_hd__mux2_1
XANTENNA__4671__A1 _5765_/Q VGND VGND VPWR VPWR sky130_fd_sc_hd__diode_2
XFILLER_53_111 VGND VGND VPWR VPWR sky130_fd_sc_hd__fill_1
XFILLER_53_166 VGND VGND VPWR VPWR sky130_fd_sc_hd__fill_2
XFILLER_53_133 VGND VGND VPWR VPWR sky130_fd_sc_hd__decap_3
X_5907_ _5942_/CLK _5907_/D fanout306/X VGND VGND VPWR VPWR _5907_/Q sky130_fd_sc_hd__dfrtp_1
XTAP_TAPCELL_ROW_52_835 VGND VPWR sky130_fd_sc_hd__tapvpwrvgnd_1
XTAP_TAPCELL_ROW_52_824 VGND VPWR sky130_fd_sc_hd__tapvpwrvgnd_1
XANTENNA__4974__A2 _4878_/A VGND VGND VPWR VPWR sky130_fd_sc_hd__diode_2
XANTENNA__3596__A _4444_/B VGND VGND VPWR VPWR sky130_fd_sc_hd__diode_2
X_5838_ _6021_/CLK _5838_/D fanout333/X VGND VGND VPWR VPWR _5838_/Q sky130_fd_sc_hd__dfrtp_1
XFILLER_14_57 VGND VGND VPWR VPWR sky130_fd_sc_hd__decap_4
XANTENNA_fanout233_X _4522_/C VGND VGND VPWR VPWR sky130_fd_sc_hd__diode_2
XPHY_EDGE_ROW_40_Right_40 VGND VGND VPWR VPWR sky130_fd_sc_hd__decap_3
X_5769_ _5788_/CLK _5769_/D fanout304/X VGND VGND VPWR VPWR _5769_/Q sky130_fd_sc_hd__dfrtp_1
XANTENNA__4187__B1 _4176_/C VGND VGND VPWR VPWR sky130_fd_sc_hd__diode_2
XTAP_TAPCELL_ROW_32_581 VGND VPWR sky130_fd_sc_hd__tapvpwrvgnd_1
XFILLER_5_207 VGND VGND VPWR VPWR sky130_fd_sc_hd__decap_6
XPHY_EDGE_ROW_12_Left_93 VGND VGND VPWR VPWR sky130_fd_sc_hd__decap_3
XFILLER_30_67 VGND VGND VPWR VPWR sky130_fd_sc_hd__fill_1
XANTENNA__4662__A1 _4678_/A1 VGND VGND VPWR VPWR sky130_fd_sc_hd__diode_2
XFILLER_55_64 VGND VGND VPWR VPWR sky130_fd_sc_hd__decap_4
XFILLER_17_369 VGND VGND VPWR VPWR sky130_fd_sc_hd__decap_3
XANTENNA__5201__D _5447_/A VGND VGND VPWR VPWR sky130_fd_sc_hd__diode_2
XFILLER_25_391 VGND VGND VPWR VPWR sky130_fd_sc_hd__fill_1
XTAP_TAPCELL_ROW_80_1178 VGND VPWR sky130_fd_sc_hd__tapvpwrvgnd_1
XFILLER_9_513 VGND VGND VPWR VPWR sky130_fd_sc_hd__decap_4
XTAP_TAPCELL_ROW_80_1189 VGND VPWR sky130_fd_sc_hd__tapvpwrvgnd_1
XANTENNA__5494__Q _5494_/Q VGND VGND VPWR VPWR sky130_fd_sc_hd__diode_2
XANTENNA__4178__B1 _4176_/C VGND VGND VPWR VPWR sky130_fd_sc_hd__diode_2
XFILLER_9_557 VGND VGND VPWR VPWR sky130_fd_sc_hd__decap_3
XFILLER_9_579 VGND VGND VPWR VPWR sky130_fd_sc_hd__fill_2
X_3120_ _5928_/Q _3144_/B _2980_/Y _5937_/Q _2977_/Y VGND VGND VPWR VPWR _3120_/X
+ sky130_fd_sc_hd__a221o_1
XANTENNA__4653__A1 _5763_/Q VGND VGND VPWR VPWR sky130_fd_sc_hd__diode_2
X_3051_ _3050_/B _5687_/Q hold427/X _3053_/S VGND VGND VPWR VPWR _5687_/D sky130_fd_sc_hd__a22o_1
XFILLER_51_615 VGND VGND VPWR VPWR sky130_fd_sc_hd__fill_1
XANTENNA__4405__A1 _4404_/A VGND VGND VPWR VPWR sky130_fd_sc_hd__diode_2
XANTENNA__4956__A2 _4878_/A VGND VGND VPWR VPWR sky130_fd_sc_hd__diode_2
X_3953_ _3954_/A _3953_/B _3953_/C VGND VGND VPWR VPWR _3955_/B sky130_fd_sc_hd__and3_1
XFILLER_35_199 VPWR VGND VPWR VGND sky130_ef_sc_hd__decap_12
X_2904_ _4970_/A0 _2827_/Y _2937_/B _5493_/Q _2903_/X VGND VGND VPWR VPWR _2904_/X
+ sky130_fd_sc_hd__o221a_1
X_3884_ _5578_/Q _3895_/C _3758_/S VGND VGND VPWR VPWR _3884_/Y sky130_fd_sc_hd__o21ai_1
XANTENNA_clkbuf_0_clk_X clkbuf_0_clk/X VGND VGND VPWR VPWR sky130_fd_sc_hd__diode_2
X_2835_ _5491_/Q _2937_/B _2833_/X _2832_/X VGND VGND VPWR VPWR _2835_/X sky130_fd_sc_hd__o211a_1
X_5623_ _5645_/CLK _5623_/D fanout315/X VGND VGND VPWR VPWR _5623_/Q sky130_fd_sc_hd__dfrtp_1
XANTENNA__4708__A2 _5109_/S VGND VGND VPWR VPWR sky130_fd_sc_hd__diode_2
X_2766_ hold98/A VGND VGND VPWR VPWR _2766_/Y sky130_fd_sc_hd__inv_2
X_5554_ _5686_/CLK _5554_/D VGND VGND VPWR VPWR hold30/A sky130_fd_sc_hd__dfxtp_1
X_5485_ _6149_/CLK _5485_/D VGND VGND VPWR VPWR hold46/A sky130_fd_sc_hd__dfxtp_1
X_4505_ _4467_/A _4487_/A _4487_/B _3639_/A _4452_/B VGND VGND VPWR VPWR _4505_/X
+ sky130_fd_sc_hd__o41a_1
X_4436_ _4434_/X _4435_/Y _4436_/S VGND VGND VPWR VPWR _4436_/X sky130_fd_sc_hd__mux2_1
X_4367_ _4354_/S _4360_/Y _4380_/B _4366_/Y VGND VGND VPWR VPWR _4367_/X sky130_fd_sc_hd__a31o_1
XANTENNA__4892__A1 _5521_/Q VGND VGND VPWR VPWR sky130_fd_sc_hd__diode_2
XFILLER_58_203 VGND VGND VPWR VPWR sky130_fd_sc_hd__fill_1
X_6106_ _6106_/CLK _6106_/D fanout273/X VGND VGND VPWR VPWR _6106_/Q sky130_fd_sc_hd__dfrtp_1
X_3318_ _3336_/A _5981_/Q VGND VGND VPWR VPWR _3361_/B sky130_fd_sc_hd__and2_1
X_4298_ _5707_/Q _4297_/X _4310_/S VGND VGND VPWR VPWR _4298_/X sky130_fd_sc_hd__mux2_1
XANTENNA_fanout183_X _2910_/B VGND VGND VPWR VPWR sky130_fd_sc_hd__diode_2
X_6037_ _6106_/CLK _6037_/D fanout274/X VGND VGND VPWR VPWR _6037_/Q sky130_fd_sc_hd__dfrtp_1
X_3249_ _6136_/Q _6133_/Q _6135_/Q _6134_/Q VGND VGND VPWR VPWR _3454_/C sky130_fd_sc_hd__or4_1
XTAP_TAPCELL_ROW_37_640 VGND VPWR sky130_fd_sc_hd__tapvpwrvgnd_1
XTAP_TAPCELL_ROW_65_993 VGND VPWR sky130_fd_sc_hd__tapvpwrvgnd_1
XFILLER_14_306 VGND VGND VPWR VPWR sky130_fd_sc_hd__fill_2
XFILLER_41_147 VGND VGND VPWR VPWR sky130_fd_sc_hd__fill_1
XFILLER_41_169 VGND VGND VPWR VPWR sky130_fd_sc_hd__fill_1
XFILLER_41_11 VGND VGND VPWR VPWR sky130_fd_sc_hd__fill_1
XFILLER_10_589 VGND VGND VPWR VPWR sky130_fd_sc_hd__decap_6
XANTENNA__4580__B1 _4684_/B1 VGND VGND VPWR VPWR sky130_fd_sc_hd__diode_2
XANTENNA__2894__B1 _2797_/X VGND VGND VPWR VPWR sky130_fd_sc_hd__diode_2
XFILLER_2_27 VGND VGND VPWR VPWR sky130_fd_sc_hd__fill_1
XANTENNA__5489__Q _5489_/Q VGND VGND VPWR VPWR sky130_fd_sc_hd__diode_2
XFILLER_17_111 VGND VGND VPWR VPWR sky130_fd_sc_hd__fill_1
XFILLER_18_623 VPWR VGND VPWR VGND sky130_ef_sc_hd__decap_12
XFILLER_33_615 VGND VGND VPWR VPWR sky130_fd_sc_hd__fill_1
XANTENNA__4938__A2 _4950_/A2 VGND VGND VPWR VPWR sky130_fd_sc_hd__diode_2
XFILLER_17_199 VGND VGND VPWR VPWR sky130_fd_sc_hd__decap_8
XTAP_TAPCELL_ROW_15_367 VGND VPWR sky130_fd_sc_hd__tapvpwrvgnd_1
XFILLER_41_670 VGND VGND VPWR VPWR sky130_fd_sc_hd__fill_2
XANTENNA__3964__A _4052_/S VGND VGND VPWR VPWR sky130_fd_sc_hd__diode_2
XANTENNA__6113__Q _6113_/Q VGND VGND VPWR VPWR sky130_fd_sc_hd__diode_2
XANTENNA__4571__B1 _4667_/B1 VGND VGND VPWR VPWR sky130_fd_sc_hd__diode_2
X_5270_ _5270_/A _5270_/B VGND VGND VPWR VPWR _5270_/X sky130_fd_sc_hd__xor2_1
X_4221_ _5790_/Q _4167_/Y _4170_/Y _5782_/Q _4168_/Y VGND VGND VPWR VPWR _4221_/X
+ sky130_fd_sc_hd__a221o_1
XFILLER_49_3 VGND VGND VPWR VPWR sky130_fd_sc_hd__decap_8
X_4152_ _4152_/A _4152_/B VGND VGND VPWR VPWR _4340_/A sky130_fd_sc_hd__nor2_1
XANTENNA__2885__B1 _2786_/X VGND VGND VPWR VPWR sky130_fd_sc_hd__diode_2
X_3103_ _5682_/Q _5683_/Q _3103_/C VGND VGND VPWR VPWR _3104_/B sky130_fd_sc_hd__and3_1
X_4083_ _4083_/A _4083_/B VGND VGND VPWR VPWR _4091_/S sky130_fd_sc_hd__or2_4
XANTENNA__4626__A1 _5793_/Q VGND VGND VPWR VPWR sky130_fd_sc_hd__diode_2
X_3034_ hold19/A hold50/A hold29/A hold32/A _3954_/A _5610_/Q VGND VGND VPWR VPWR
+ _3034_/X sky130_fd_sc_hd__mux4_1
XTAP_TAPCELL_ROW_34_610 VGND VPWR sky130_fd_sc_hd__tapvpwrvgnd_1
XFILLER_36_475 VGND VGND VPWR VPWR sky130_fd_sc_hd__fill_1
XTAP_TAPCELL_ROW_62_952 VGND VPWR sky130_fd_sc_hd__tapvpwrvgnd_1
X_4985_ hold399/X _5043_/A2 _4984_/X VGND VGND VPWR VPWR _5938_/D sky130_fd_sc_hd__a21o_1
X_3936_ hold471/X _3548_/Y _3940_/S VGND VGND VPWR VPWR _5594_/D sky130_fd_sc_hd__mux2_1
XANTENNA_fanout143_A _4876_/Y VGND VGND VPWR VPWR sky130_fd_sc_hd__diode_2
XFILLER_31_191 VPWR VGND VPWR VGND sky130_ef_sc_hd__decap_12
X_3867_ _3388_/X _3767_/A _3865_/X _3783_/A VGND VGND VPWR VPWR _4108_/B sky130_fd_sc_hd__a22oi_2
X_3798_ _5571_/Q _3811_/C VGND VGND VPWR VPWR _3798_/X sky130_fd_sc_hd__and2_1
XANTENNA_fanout310_A fanout324/X VGND VGND VPWR VPWR sky130_fd_sc_hd__diode_2
X_5606_ _5685_/CLK _5606_/D fanout315/X VGND VGND VPWR VPWR _5606_/Q sky130_fd_sc_hd__dfrtp_1
X_2818_ _5754_/Q _2964_/B VGND VGND VPWR VPWR _3240_/A sky130_fd_sc_hd__or2_2
XANTENNA__4562__A0 _5487_/Q VGND VGND VPWR VPWR sky130_fd_sc_hd__diode_2
X_2749_ _6061_/Q VGND VGND VPWR VPWR _2749_/Y sky130_fd_sc_hd__inv_2
X_5537_ _6149_/CLK _5537_/D VGND VGND VPWR VPWR hold58/A sky130_fd_sc_hd__dfxtp_1
XFILLER_78_309 VGND VGND VPWR VPWR sky130_fd_sc_hd__fill_1
X_5468_ _6144_/CLK _5468_/D fanout329/X VGND VGND VPWR VPWR _5468_/Q sky130_fd_sc_hd__dfrtp_4
Xfanout300 fanout303/X VGND VGND VPWR VPWR fanout300/X sky130_fd_sc_hd__clkbuf_4
X_4419_ _4418_/A _4418_/B _4418_/Y _4354_/S VGND VGND VPWR VPWR _4419_/Y sky130_fd_sc_hd__a211oi_1
Xfanout311 fanout324/X VGND VGND VPWR VPWR fanout311/X sky130_fd_sc_hd__buf_2
X_5399_ _5409_/A _5399_/B VGND VGND VPWR VPWR _5402_/B sky130_fd_sc_hd__nor2_1
Xfanout322 fanout323/X VGND VGND VPWR VPWR fanout322/X sky130_fd_sc_hd__clkbuf_2
XANTENNA__6030__RESET_B fanout292/X VGND VGND VPWR VPWR sky130_fd_sc_hd__diode_2
Xfanout344 fanout346/X VGND VGND VPWR VPWR fanout344/X sky130_fd_sc_hd__clkbuf_4
Xfanout333 fanout334/X VGND VGND VPWR VPWR fanout333/X sky130_fd_sc_hd__clkbuf_4
XFILLER_15_615 VGND VGND VPWR VPWR sky130_fd_sc_hd__fill_1
XANTENNA__2953__A _5599_/Q VGND VGND VPWR VPWR sky130_fd_sc_hd__diode_2
XFILLER_27_475 VGND VGND VPWR VPWR sky130_fd_sc_hd__fill_2
XTAP_TAPCELL_ROW_12_326 VGND VPWR sky130_fd_sc_hd__tapvpwrvgnd_1
XANTENNA__2800__B1 _2886_/B VGND VGND VPWR VPWR sky130_fd_sc_hd__diode_2
XFILLER_10_331 VGND VGND VPWR VPWR sky130_fd_sc_hd__fill_1
XANTENNA__3784__A _5200_/C VGND VGND VPWR VPWR sky130_fd_sc_hd__diode_2
XTAP_TAPCELL_ROW_40_679 VGND VPWR sky130_fd_sc_hd__tapvpwrvgnd_1
XFILLER_10_397 VGND VGND VPWR VPWR sky130_fd_sc_hd__decap_8
XFILLER_6_357 VGND VGND VPWR VPWR sky130_fd_sc_hd__decap_6
XANTENNA__4553__B1 _3554_/Y VGND VGND VPWR VPWR sky130_fd_sc_hd__diode_2
XANTENNA__2867__B1 _2910_/B VGND VGND VPWR VPWR sky130_fd_sc_hd__diode_2
XFILLER_77_95 VGND VGND VPWR VPWR sky130_fd_sc_hd__fill_2
XANTENNA__4608__A1 _4672_/A1 VGND VGND VPWR VPWR sky130_fd_sc_hd__diode_2
XFILLER_65_559 VGND VGND VPWR VPWR sky130_fd_sc_hd__fill_1
XFILLER_18_442 VPWR VGND VPWR VGND sky130_ef_sc_hd__decap_12
XTAP_TAPCELL_ROW_48_779 VGND VPWR sky130_fd_sc_hd__tapvpwrvgnd_1
XFILLER_18_475 VGND VGND VPWR VPWR sky130_fd_sc_hd__fill_1
XANTENNA__4792__A0 _5492_/Q VGND VGND VPWR VPWR sky130_fd_sc_hd__diode_2
XFILLER_60_275 VGND VGND VPWR VPWR sky130_fd_sc_hd__fill_1
X_4770_ hold121/X _3829_/X _4776_/S VGND VGND VPWR VPWR _5808_/D sky130_fd_sc_hd__mux2_1
X_3721_ _3721_/A _3721_/B _3721_/C _3721_/D VGND VGND VPWR VPWR _3721_/Y sky130_fd_sc_hd__nor4_1
X_3652_ _4464_/A _6040_/Q VGND VGND VPWR VPWR _3698_/D sky130_fd_sc_hd__and2_1
X_3583_ _6104_/Q _3656_/A VGND VGND VPWR VPWR _3709_/A sky130_fd_sc_hd__nor2_1
X_5322_ hold355/X _5341_/B2 _5321_/X VGND VGND VPWR VPWR _6156_/D sky130_fd_sc_hd__a21bo_1
X_5253_ _5341_/B2 fanout9/X _5258_/A VGND VGND VPWR VPWR _6145_/D sky130_fd_sc_hd__mux2_1
X_4204_ _5772_/Q _4169_/X _4203_/X _3192_/B VGND VGND VPWR VPWR _4209_/A sky130_fd_sc_hd__o211a_1
X_5184_ hold316/X _3647_/A _5186_/S VGND VGND VPWR VPWR _6106_/D sky130_fd_sc_hd__mux2_1
X_4135_ _4133_/X _4134_/Y _4247_/A _4329_/A VGND VGND VPWR VPWR _4135_/X sky130_fd_sc_hd__o2bb2a_1
XFILLER_71_507 VGND VGND VPWR VPWR sky130_fd_sc_hd__fill_1
X_4066_ hold479/X _3976_/B _3978_/A VGND VGND VPWR VPWR _4066_/X sky130_fd_sc_hd__a21o_1
XANTENNA__3869__A _5201_/B VGND VGND VPWR VPWR sky130_fd_sc_hd__diode_2
X_3017_ hold208/X _3016_/X _3114_/S VGND VGND VPWR VPWR _6121_/D sky130_fd_sc_hd__mux2_1
XFILLER_24_412 VGND VGND VPWR VPWR sky130_fd_sc_hd__fill_1
XANTENNA__4783__A0 _5521_/Q VGND VGND VPWR VPWR sky130_fd_sc_hd__diode_2
X_4968_ _4735_/X _4878_/A _4878_/B _4967_/X VGND VGND VPWR VPWR _4968_/X sky130_fd_sc_hd__a22o_1
X_4899_ _4232_/X _4971_/A2 _4971_/B1 _4898_/X VGND VGND VPWR VPWR _4899_/X sky130_fd_sc_hd__a22o_1
XFILLER_20_640 VGND VGND VPWR VPWR sky130_fd_sc_hd__decap_4
X_3919_ _5582_/Q _3240_/B _3549_/Y _3918_/X VGND VGND VPWR VPWR _5582_/D sky130_fd_sc_hd__a22o_1
XFILLER_22_57 VGND VGND VPWR VPWR sky130_fd_sc_hd__decap_8
XANTENNA_fanout313_X fanout313/X VGND VGND VPWR VPWR sky130_fd_sc_hd__diode_2
XANTENNA__6130__D _6130_/D VGND VGND VPWR VPWR sky130_fd_sc_hd__diode_2
XFILLER_3_305 VPWR VGND VPWR VGND sky130_ef_sc_hd__decap_12
XANTENNA__4639__S _4687_/S VGND VGND VPWR VPWR sky130_fd_sc_hd__diode_2
XFILLER_78_139 VGND VGND VPWR VPWR sky130_fd_sc_hd__fill_1
Xfanout130 _4810_/S VGND VGND VPWR VPWR _4807_/S sky130_fd_sc_hd__clkbuf_4
Xfanout174 _2792_/Y VGND VGND VPWR VPWR _2926_/B1 sky130_fd_sc_hd__buf_2
Xfanout141 _5026_/A2 VGND VGND VPWR VPWR _5024_/A2 sky130_fd_sc_hd__clkbuf_4
Xfanout163 _2972_/Y VGND VGND VPWR VPWR _4735_/S sky130_fd_sc_hd__clkbuf_4
Xfanout152 _5189_/A2 VGND VGND VPWR VPWR _4761_/A2 sky130_fd_sc_hd__clkbuf_2
Xfanout185 _2782_/Y VGND VGND VPWR VPWR _2895_/C sky130_fd_sc_hd__clkbuf_2
Xfanout196 _5369_/A VGND VGND VPWR VPWR _3749_/A sky130_fd_sc_hd__buf_2
XFILLER_47_54 VGND VGND VPWR VPWR sky130_fd_sc_hd__fill_2
XANTENNA_fanout59_X _4684_/A2 VGND VGND VPWR VPWR sky130_fd_sc_hd__diode_2
XFILLER_63_31 VGND VGND VPWR VPWR sky130_fd_sc_hd__decap_4
XANTENNA__5767__Q _5767_/Q VGND VGND VPWR VPWR sky130_fd_sc_hd__diode_2
XTAP_TAPCELL_ROW_45_738 VGND VPWR sky130_fd_sc_hd__tapvpwrvgnd_1
XPHY_EDGE_ROW_69_Right_69 VGND VGND VPWR VPWR sky130_fd_sc_hd__decap_3
XFILLER_63_64 VGND VGND VPWR VPWR sky130_fd_sc_hd__decap_6
XFILLER_63_53 VGND VGND VPWR VPWR sky130_fd_sc_hd__decap_3
XFILLER_42_253 VPWR VGND VPWR VGND sky130_ef_sc_hd__decap_12
XTAP_TAPCELL_ROW_25_495 VGND VPWR sky130_fd_sc_hd__tapvpwrvgnd_1
XFILLER_11_673 VGND VGND VPWR VPWR sky130_fd_sc_hd__fill_1
XFILLER_11_662 VGND VGND VPWR VPWR sky130_fd_sc_hd__fill_1
XFILLER_10_194 VGND VGND VPWR VPWR sky130_fd_sc_hd__fill_2
XFILLER_7_666 VGND VGND VPWR VPWR sky130_fd_sc_hd__decap_6
XTAP_TAPCELL_ROW_77_1139 VGND VPWR sky130_fd_sc_hd__tapvpwrvgnd_1
XFILLER_7_699 VPWR VGND VPWR VGND sky130_ef_sc_hd__decap_12
XPHY_EDGE_ROW_78_Right_78 VGND VGND VPWR VPWR sky130_fd_sc_hd__decap_3
XANTENNA__5934__RESET_B fanout306/X VGND VGND VPWR VPWR sky130_fd_sc_hd__diode_2
XPHY_EDGE_ROW_0_Left_81 VGND VGND VPWR VPWR sky130_fd_sc_hd__decap_3
XFILLER_2_371 VGND VGND VPWR VPWR sky130_fd_sc_hd__fill_1
X_5940_ _5942_/CLK _5940_/D fanout306/X VGND VGND VPWR VPWR _5940_/Q sky130_fd_sc_hd__dfrtp_1
XFILLER_80_359 VGND VGND VPWR VPWR sky130_fd_sc_hd__decap_4
X_5871_ _6092_/CLK _5871_/D fanout342/X VGND VGND VPWR VPWR _5871_/Q sky130_fd_sc_hd__dfrtp_1
X_4822_ _4522_/B _4824_/A2 _4811_/X hold142/X VGND VGND VPWR VPWR _5858_/D sky130_fd_sc_hd__a22o_1
X_4753_ hold195/X _4753_/A2 _4752_/X VGND VGND VPWR VPWR _5792_/D sky130_fd_sc_hd__o21a_1
X_3704_ _3704_/A VGND VGND VPWR VPWR _3704_/Y sky130_fd_sc_hd__inv_2
X_4684_ _5926_/Q _4684_/A2 _4684_/B1 _4683_/X VGND VGND VPWR VPWR _4684_/X sky130_fd_sc_hd__a211o_1
X_3635_ _4530_/A _6045_/Q VGND VGND VPWR VPWR _3720_/A sky130_fd_sc_hd__and2_1
XANTENNA_fanout106_A _4878_/Y VGND VGND VPWR VPWR sky130_fd_sc_hd__diode_2
XANTENNA__4600__X _4600_/X VGND VGND VPWR VPWR sky130_fd_sc_hd__diode_2
X_3566_ _5195_/B _5226_/C _3491_/X VGND VGND VPWR VPWR _3663_/B sky130_fd_sc_hd__a21o_1
XANTENNA__5190__B1 _4539_/X VGND VGND VPWR VPWR sky130_fd_sc_hd__diode_2
X_5305_ _6153_/Q _5343_/B _5303_/B VGND VGND VPWR VPWR _5307_/A sky130_fd_sc_hd__a21oi_1
XANTENNA__2768__A _5736_/Q VGND VGND VPWR VPWR sky130_fd_sc_hd__diode_2
X_3497_ _3565_/A _3549_/A VGND VGND VPWR VPWR _3508_/A sky130_fd_sc_hd__nor2_1
X_5236_ hold408/X _5362_/B _5231_/X _5233_/X VGND VGND VPWR VPWR _6136_/D sky130_fd_sc_hd__a211o_1
X_5167_ hold203/X _5727_/Q _5167_/S VGND VGND VPWR VPWR _6089_/D sky130_fd_sc_hd__mux2_1
X_5098_ hold245/X _5477_/Q _5098_/S VGND VGND VPWR VPWR _6021_/D sky130_fd_sc_hd__mux2_1
X_4118_ _5578_/Q _4118_/B VGND VGND VPWR VPWR _4126_/A sky130_fd_sc_hd__xor2_1
XFILLER_29_559 VGND VGND VPWR VPWR sky130_fd_sc_hd__fill_1
X_4049_ hold82/X _3975_/Y _4047_/X _4048_/X VGND VGND VPWR VPWR _5662_/D sky130_fd_sc_hd__a22o_1
XFILLER_71_337 VGND VGND VPWR VPWR sky130_fd_sc_hd__fill_1
XFILLER_17_57 VGND VGND VPWR VPWR sky130_fd_sc_hd__fill_1
XFILLER_17_79 VGND VGND VPWR VPWR sky130_fd_sc_hd__decap_3
XTAP_TAPCELL_ROW_42_708 VGND VPWR sky130_fd_sc_hd__tapvpwrvgnd_1
XANTENNA__4756__B1 _4828_/B2 VGND VGND VPWR VPWR sky130_fd_sc_hd__diode_2
XTAP_TAPCELL_ROW_22_454 VGND VPWR sky130_fd_sc_hd__tapvpwrvgnd_1
Xtt_um_bfcpu_369 VGND VGND VPWR VPWR tt_um_bfcpu_369/HI uo_out[7] sky130_fd_sc_hd__conb_1
Xtt_um_bfcpu_358 VGND VGND VPWR VPWR tt_um_bfcpu_358/HI uio_out[3] sky130_fd_sc_hd__conb_1
Xhold8 hold8/A VGND VGND VPWR VPWR hold8/X sky130_fd_sc_hd__dlygate4sd3_1
XANTENNA__2965__X _2965_/X VGND VGND VPWR VPWR sky130_fd_sc_hd__diode_2
XFILLER_74_85 VPWR VGND VPWR VGND sky130_ef_sc_hd__decap_12
XFILLER_62_326 VGND VGND VPWR VPWR sky130_fd_sc_hd__fill_1
XFILLER_15_275 VGND VGND VPWR VPWR sky130_fd_sc_hd__decap_4
XANTENNA__4747__B1 _4747_/B1 VGND VGND VPWR VPWR sky130_fd_sc_hd__diode_2
Xhold408 _6136_/Q VGND VGND VPWR VPWR hold408/X sky130_fd_sc_hd__dlygate4sd3_1
Xmax_cap138 _4333_/S VGND VGND VPWR VPWR _4336_/S sky130_fd_sc_hd__clkbuf_2
X_3420_ _5637_/Q hold67/X _3961_/A VGND VGND VPWR VPWR _5535_/D sky130_fd_sc_hd__mux2_1
Xhold419 _6030_/Q VGND VGND VPWR VPWR hold419/X sky130_fd_sc_hd__dlygate4sd3_1
XANTENNA__4279__S _5458_/C VGND VGND VPWR VPWR sky130_fd_sc_hd__diode_2
X_3351_ _3351_/A _3351_/B _3351_/C _3351_/D VGND VGND VPWR VPWR _3351_/X sky130_fd_sc_hd__or4_1
XFILLER_31_3 VGND VGND VPWR VPWR sky130_fd_sc_hd__fill_2
X_6070_ _6094_/CLK _6070_/D fanout349/X VGND VGND VPWR VPWR _6070_/Q sky130_fd_sc_hd__dfrtp_1
X_3282_ _3356_/A _3354_/A _3282_/C _3282_/D VGND VGND VPWR VPWR _3295_/A sky130_fd_sc_hd__or4_1
X_5021_ hold397/X _5043_/A2 _5020_/X VGND VGND VPWR VPWR _5956_/D sky130_fd_sc_hd__a21o_1
XFILLER_66_643 VGND VGND VPWR VPWR sky130_fd_sc_hd__fill_1
XFILLER_53_304 VGND VGND VPWR VPWR sky130_fd_sc_hd__fill_1
XFILLER_65_186 VPWR VGND VPWR VGND sky130_ef_sc_hd__decap_12
X_5923_ _5963_/CLK _5923_/D fanout307/X VGND VGND VPWR VPWR _5923_/Q sky130_fd_sc_hd__dfrtp_1
XANTENNA__4986__B1 _5026_/B1 VGND VGND VPWR VPWR sky130_fd_sc_hd__diode_2
X_5854_ _6026_/CLK _5854_/D fanout277/X VGND VGND VPWR VPWR _5854_/Q sky130_fd_sc_hd__dfrtp_1
X_4805_ _5094_/A1 hold342/X _4805_/S VGND VGND VPWR VPWR _5842_/D sky130_fd_sc_hd__mux2_1
XANTENNA__4738__A0 _5799_/Q VGND VGND VPWR VPWR sky130_fd_sc_hd__diode_2
X_5785_ _5788_/CLK _5785_/D fanout297/X VGND VGND VPWR VPWR _5785_/Q sky130_fd_sc_hd__dfrtp_1
X_2997_ _6095_/Q _3150_/C VGND VGND VPWR VPWR _4674_/S sky130_fd_sc_hd__and2b_2
XFILLER_21_256 VGND VGND VPWR VPWR sky130_fd_sc_hd__fill_2
X_4736_ _4226_/S _4735_/X _4734_/X _3877_/S VGND VGND VPWR VPWR _4736_/X sky130_fd_sc_hd__a211o_1
X_4667_ _5924_/Q _4747_/A2 _4667_/B1 _4666_/X VGND VGND VPWR VPWR _4667_/X sky130_fd_sc_hd__a22o_1
XANTENNA_fanout109_X _4863_/S VGND VGND VPWR VPWR sky130_fd_sc_hd__diode_2
X_3618_ _4522_/A _5975_/Q VGND VGND VPWR VPWR _3620_/B sky130_fd_sc_hd__xnor2_1
X_4598_ _4678_/A1 _4597_/X _4686_/B1 VGND VGND VPWR VPWR _4598_/X sky130_fd_sc_hd__o21a_1
XANTENNA__4910__A0 _5489_/Q VGND VGND VPWR VPWR sky130_fd_sc_hd__diode_2
XANTENNA__4189__S _4226_/S VGND VGND VPWR VPWR sky130_fd_sc_hd__diode_2
X_3549_ _3549_/A _3550_/B VGND VGND VPWR VPWR _3549_/Y sky130_fd_sc_hd__xnor2_2
X_5219_ _6125_/Q _5219_/B VGND VGND VPWR VPWR _5220_/B sky130_fd_sc_hd__xnor2_1
XFILLER_28_56 VPWR VGND VPWR VGND sky130_ef_sc_hd__decap_12
XFILLER_29_334 VGND VGND VPWR VPWR sky130_fd_sc_hd__fill_2
XANTENNA__3229__A0 _4973_/A0 VGND VGND VPWR VPWR sky130_fd_sc_hd__diode_2
XFILLER_56_153 VGND VGND VPWR VPWR sky130_fd_sc_hd__fill_1
XTAP_TAPCELL_ROW_27_513 VGND VPWR sky130_fd_sc_hd__tapvpwrvgnd_1
XTAP_TAPCELL_ROW_55_866 VGND VPWR sky130_fd_sc_hd__tapvpwrvgnd_1
XFILLER_44_77 VGND VGND VPWR VPWR sky130_fd_sc_hd__decap_6
XANTENNA_clkbuf_leaf_22_clk_A clkload2/A VGND VGND VPWR VPWR sky130_fd_sc_hd__diode_2
XFILLER_8_205 VGND VGND VPWR VPWR sky130_fd_sc_hd__fill_1
XFILLER_40_587 VGND VGND VPWR VPWR sky130_fd_sc_hd__fill_1
XANTENNA__3401__A0 _2843_/B VGND VGND VPWR VPWR sky130_fd_sc_hd__diode_2
XTAP_TAPCELL_ROW_74_1109 VGND VPWR sky130_fd_sc_hd__tapvpwrvgnd_1
XFILLER_4_433 VPWR VGND VPWR VGND sky130_ef_sc_hd__decap_12
XANTENNA__3165__C1 _2977_/Y VGND VGND VPWR VPWR sky130_fd_sc_hd__diode_2
XANTENNA_clkbuf_leaf_37_clk_A clkload1/A VGND VGND VPWR VPWR sky130_fd_sc_hd__diode_2
XANTENNA__5457__A1 _3905_/A VGND VGND VPWR VPWR sky130_fd_sc_hd__diode_2
XTAP_TAPCELL_ROW_7_271 VGND VPWR sky130_fd_sc_hd__tapvpwrvgnd_1
XFILLER_48_643 VGND VGND VPWR VPWR sky130_fd_sc_hd__fill_1
Xclkbuf_2_3__f_clk clkbuf_0_clk/X VGND VGND VPWR VPWR clkload2/A sky130_fd_sc_hd__clkbuf_16
XANTENNA_clkload1_A clkload1/A VGND VGND VPWR VPWR sky130_fd_sc_hd__diode_2
XFILLER_35_337 VGND VGND VPWR VPWR sky130_fd_sc_hd__fill_1
XANTENNA__4968__B1 _4878_/B VGND VGND VPWR VPWR sky130_fd_sc_hd__diode_2
X_2920_ _2925_/D _2920_/B _2925_/B _5898_/Q VGND VGND VPWR VPWR _2920_/X sky130_fd_sc_hd__and4_1
XFILLER_43_381 VGND VGND VPWR VPWR sky130_fd_sc_hd__fill_2
X_2851_ _2848_/X _2849_/X _2850_/X VGND VGND VPWR VPWR _2851_/X sky130_fd_sc_hd__a21o_1
XANTENNA__4196__A1 _5762_/Q VGND VGND VPWR VPWR sky130_fd_sc_hd__diode_2
XANTENNA__3608__A_N _3647_/A VGND VGND VPWR VPWR sky130_fd_sc_hd__diode_2
XFILLER_79_3 VPWR VGND VPWR VGND sky130_ef_sc_hd__decap_12
X_2782_ _2920_/B _2925_/B VGND VGND VPWR VPWR _2782_/Y sky130_fd_sc_hd__nor2_1
X_5570_ _5811_/CLK _5570_/D fanout288/X VGND VGND VPWR VPWR _5570_/Q sky130_fd_sc_hd__dfrtp_1
X_4521_ _4522_/C _4521_/B VGND VGND VPWR VPWR _4533_/B sky130_fd_sc_hd__nor2_1
XANTENNA__3943__A1 _3554_/Y VGND VGND VPWR VPWR sky130_fd_sc_hd__diode_2
Xhold216 _6017_/Q VGND VGND VPWR VPWR hold216/X sky130_fd_sc_hd__dlygate4sd3_1
Xhold205 _6064_/Q VGND VGND VPWR VPWR hold205/X sky130_fd_sc_hd__dlygate4sd3_1
X_4452_ _4452_/A _4452_/B VGND VGND VPWR VPWR _4479_/A sky130_fd_sc_hd__xnor2_1
X_3403_ _2934_/B _5520_/Q _3407_/S VGND VGND VPWR VPWR _5520_/D sky130_fd_sc_hd__mux2_1
Xhold238 _5845_/Q VGND VGND VPWR VPWR hold238/X sky130_fd_sc_hd__dlygate4sd3_1
Xhold227 _5996_/Q VGND VGND VPWR VPWR hold227/X sky130_fd_sc_hd__dlygate4sd3_1
Xhold249 _5868_/Q VGND VGND VPWR VPWR hold249/X sky130_fd_sc_hd__dlygate4sd3_1
X_4383_ _4829_/C _4384_/B VGND VGND VPWR VPWR _4408_/C sky130_fd_sc_hd__and2_1
XANTENNA__3171__A2 _2965_/X VGND VGND VPWR VPWR sky130_fd_sc_hd__diode_2
X_6122_ _6161_/CLK _6122_/D fanout313/X VGND VGND VPWR VPWR _6122_/Q sky130_fd_sc_hd__dfrtp_1
XANTENNA__5448__A1 _6174_/Q VGND VGND VPWR VPWR sky130_fd_sc_hd__diode_2
X_3334_ _5412_/A _3272_/B _3270_/B _5201_/B VGND VGND VPWR VPWR _3354_/B sky130_fd_sc_hd__a22o_1
XFILLER_58_429 VGND VGND VPWR VPWR sky130_fd_sc_hd__fill_1
X_6053_ clkload9/A _6053_/D fanout282/X VGND VGND VPWR VPWR _6053_/Q sky130_fd_sc_hd__dfrtp_1
X_3265_ _6130_/D _3265_/B VGND VGND VPWR VPWR _3928_/A sky130_fd_sc_hd__nand2_1
XANTENNA__4656__C1 _4720_/C1 VGND VGND VPWR VPWR sky130_fd_sc_hd__diode_2
X_5004_ _4597_/X _5024_/A2 _5024_/B1 _4916_/X VGND VGND VPWR VPWR _5004_/X sky130_fd_sc_hd__a22o_1
X_3196_ _2824_/C _5467_/Q _3203_/S VGND VGND VPWR VPWR _5467_/D sky130_fd_sc_hd__mux2_1
XANTENNA_fanout173_A _2926_/B1 VGND VGND VPWR VPWR sky130_fd_sc_hd__diode_2
XANTENNA__4959__B1 _4878_/B VGND VGND VPWR VPWR sky130_fd_sc_hd__diode_2
XANTENNA__6055__RESET_B fanout283/X VGND VGND VPWR VPWR sky130_fd_sc_hd__diode_2
XFILLER_26_348 VGND VGND VPWR VPWR sky130_fd_sc_hd__decap_6
XANTENNA_fanout340_A fanout341/X VGND VGND VPWR VPWR sky130_fd_sc_hd__diode_2
X_5906_ _5967_/CLK _5906_/D fanout307/X VGND VGND VPWR VPWR _5906_/Q sky130_fd_sc_hd__dfrtp_1
XTAP_TAPCELL_ROW_52_836 VGND VPWR sky130_fd_sc_hd__tapvpwrvgnd_1
XTAP_TAPCELL_ROW_52_825 VGND VPWR sky130_fd_sc_hd__tapvpwrvgnd_1
X_5837_ _6092_/CLK _5837_/D fanout336/X VGND VGND VPWR VPWR _5837_/Q sky130_fd_sc_hd__dfrtp_1
XFILLER_22_576 VPWR VGND VPWR VGND sky130_ef_sc_hd__decap_12
X_5768_ _6131_/CLK _5768_/D fanout328/X VGND VGND VPWR VPWR _5768_/Q sky130_fd_sc_hd__dfrtp_1
XTAP_TAPCELL_ROW_32_582 VGND VPWR sky130_fd_sc_hd__tapvpwrvgnd_1
X_4719_ _5763_/Q _5930_/Q _4735_/S VGND VGND VPWR VPWR _4719_/X sky130_fd_sc_hd__mux2_1
XANTENNA__3934__A1 _3554_/Y VGND VGND VPWR VPWR sky130_fd_sc_hd__diode_2
X_5699_ _3182_/A1 _5699_/D fanout297/X VGND VGND VPWR VPWR _5699_/Q sky130_fd_sc_hd__dfrtp_4
XANTENNA__3162__A2 _2965_/X VGND VGND VPWR VPWR sky130_fd_sc_hd__diode_2
XFILLER_1_447 VGND VGND VPWR VPWR sky130_fd_sc_hd__fill_1
XANTENNA__4647__S _4687_/S VGND VGND VPWR VPWR sky130_fd_sc_hd__diode_2
XANTENNA__2956__A _3240_/B VGND VGND VPWR VPWR sky130_fd_sc_hd__diode_2
XTAP_TAPCELL_ROW_4_230 VGND VPWR sky130_fd_sc_hd__tapvpwrvgnd_1
XFILLER_17_337 VGND VGND VPWR VPWR sky130_fd_sc_hd__decap_3
XFILLER_45_635 VGND VGND VPWR VPWR sky130_fd_sc_hd__decap_6
XANTENNA_fanout41_X _4667_/B1 VGND VGND VPWR VPWR sky130_fd_sc_hd__diode_2
XFILLER_45_657 VGND VGND VPWR VPWR sky130_fd_sc_hd__fill_1
XFILLER_9_503 VGND VGND VPWR VPWR sky130_fd_sc_hd__fill_1
XTAP_TAPCELL_ROW_80_1179 VGND VPWR sky130_fd_sc_hd__tapvpwrvgnd_1
XANTENNA__3925__B2 _3918_/X VGND VGND VPWR VPWR sky130_fd_sc_hd__diode_2
XANTENNA__4638__C1 _4750_/C1 VGND VGND VPWR VPWR sky130_fd_sc_hd__diode_2
X_3050_ _5647_/Q _3050_/B VGND VGND VPWR VPWR _3053_/S sky130_fd_sc_hd__nor2_1
XFILLER_35_178 VPWR VGND VPWR VGND sky130_ef_sc_hd__decap_12
X_3952_ _3953_/B _3953_/C VGND VGND VPWR VPWR _3954_/B sky130_fd_sc_hd__nand2_1
X_2903_ _5473_/Q _2823_/Y _2935_/B _5469_/Q VGND VGND VPWR VPWR _2903_/X sky130_fd_sc_hd__o22a_1
X_3883_ _5577_/Q _5578_/Q _3883_/C VGND VGND VPWR VPWR _3896_/B sky130_fd_sc_hd__and3_1
XANTENNA__3984__X _4005_/S VGND VGND VPWR VPWR sky130_fd_sc_hd__diode_2
X_2834_ _2833_/A _2934_/A _2834_/C VGND VGND VPWR VPWR _2937_/B sky130_fd_sc_hd__nand3b_2
X_5622_ _6088_/CLK _5622_/D VGND VGND VPWR VPWR hold92/A sky130_fd_sc_hd__dfxtp_1
X_5553_ _5686_/CLK _5553_/D VGND VGND VPWR VPWR hold28/A sky130_fd_sc_hd__dfxtp_1
X_2765_ _5688_/Q VGND VGND VPWR VPWR _2765_/Y sky130_fd_sc_hd__inv_2
X_4504_ _4504_/A _4504_/B VGND VGND VPWR VPWR _4507_/A sky130_fd_sc_hd__and2_1
X_5484_ _6149_/CLK _5484_/D VGND VGND VPWR VPWR hold20/A sky130_fd_sc_hd__dfxtp_1
X_4435_ _4447_/A _4447_/C VGND VGND VPWR VPWR _4435_/Y sky130_fd_sc_hd__xnor2_1
X_4366_ _4364_/X _4365_/Y _4354_/S VGND VGND VPWR VPWR _4366_/Y sky130_fd_sc_hd__a21oi_1
X_6105_ _6106_/CLK _6105_/D fanout273/X VGND VGND VPWR VPWR _6105_/Q sky130_fd_sc_hd__dfrtp_1
X_3317_ _3336_/A _5981_/Q VGND VGND VPWR VPWR _3364_/D sky130_fd_sc_hd__nor2_1
X_4297_ _4227_/X _4296_/X _5458_/C VGND VGND VPWR VPWR _4297_/X sky130_fd_sc_hd__mux2_1
XANTENNA_fanout290_A fanout292/X VGND VGND VPWR VPWR sky130_fd_sc_hd__diode_2
X_6036_ _6106_/CLK _6036_/D fanout274/X VGND VGND VPWR VPWR _6036_/Q sky130_fd_sc_hd__dfrtp_1
X_3248_ _4350_/A _3248_/B VGND VGND VPWR VPWR _3549_/A sky130_fd_sc_hd__or2_4
X_3179_ _5715_/Q _3179_/B VGND VGND VPWR VPWR uio_oe[7] sky130_fd_sc_hd__nor2_4
XANTENNA_fanout176_X _2927_/B1 VGND VGND VPWR VPWR sky130_fd_sc_hd__diode_2
XFILLER_66_292 VGND VGND VPWR VPWR sky130_fd_sc_hd__fill_1
XTAP_TAPCELL_ROW_37_641 VGND VPWR sky130_fd_sc_hd__tapvpwrvgnd_1
XTAP_TAPCELL_ROW_65_994 VGND VPWR sky130_fd_sc_hd__tapvpwrvgnd_1
XFILLER_25_57 VGND VGND VPWR VPWR sky130_fd_sc_hd__fill_2
XFILLER_10_568 VGND VGND VPWR VPWR sky130_fd_sc_hd__fill_1
XFILLER_2_701 VPWR VGND VPWR VGND sky130_ef_sc_hd__decap_12
XFILLER_9_3 VGND VGND VPWR VPWR sky130_fd_sc_hd__decap_3
XFILLER_57_270 VGND VGND VPWR VPWR sky130_fd_sc_hd__fill_1
XANTENNA__4635__A2 _4747_/A2 VGND VGND VPWR VPWR sky130_fd_sc_hd__diode_2
XFILLER_18_635 VGND VGND VPWR VPWR sky130_fd_sc_hd__decap_4
XFILLER_72_262 VGND VGND VPWR VPWR sky130_fd_sc_hd__fill_1
XANTENNA__5959__RESET_B fanout307/X VGND VGND VPWR VPWR sky130_fd_sc_hd__diode_2
XFILLER_60_457 VGND VGND VPWR VPWR sky130_fd_sc_hd__fill_1
XTAP_TAPCELL_ROW_15_368 VGND VPWR sky130_fd_sc_hd__tapvpwrvgnd_1
XANTENNA__4840__S _4864_/S VGND VGND VPWR VPWR sky130_fd_sc_hd__diode_2
XFILLER_9_388 VGND VGND VPWR VPWR sky130_fd_sc_hd__decap_4
XFILLER_5_550 VGND VGND VPWR VPWR sky130_fd_sc_hd__decap_8
XFILLER_5_561 VGND VGND VPWR VPWR sky130_fd_sc_hd__fill_1
X_4220_ _5941_/Q _5765_/Q _4241_/S VGND VGND VPWR VPWR _4220_/X sky130_fd_sc_hd__mux2_1
XFILLER_5_594 VGND VGND VPWR VPWR sky130_fd_sc_hd__decap_4
XANTENNA__2885__A1 _2895_/A VGND VGND VPWR VPWR sky130_fd_sc_hd__diode_2
X_4151_ _4320_/A _4151_/B VGND VGND VPWR VPWR _4152_/B sky130_fd_sc_hd__or2_1
X_3102_ hold470/X _3103_/C _3101_/Y VGND VGND VPWR VPWR _5682_/D sky130_fd_sc_hd__o21a_1
X_4082_ _5676_/Q _3240_/B _3940_/S VGND VGND VPWR VPWR _5676_/D sky130_fd_sc_hd__a21o_1
X_3033_ _5676_/Q _5598_/Q _2958_/X _5607_/Q VGND VGND VPWR VPWR _3033_/X sky130_fd_sc_hd__a22o_1
XFILLER_36_421 VPWR VGND VPWR VGND sky130_ef_sc_hd__decap_12
XTAP_TAPCELL_ROW_34_600 VGND VPWR sky130_fd_sc_hd__tapvpwrvgnd_1
X_4984_ _4193_/X _5038_/A2 _5038_/B1 _4886_/X VGND VGND VPWR VPWR _4984_/X sky130_fd_sc_hd__a22o_1
XTAP_TAPCELL_ROW_34_611 VGND VPWR sky130_fd_sc_hd__tapvpwrvgnd_1
XTAP_TAPCELL_ROW_62_953 VGND VPWR sky130_fd_sc_hd__tapvpwrvgnd_1
X_3935_ _5593_/Q _3559_/Y _3940_/S VGND VGND VPWR VPWR _5593_/D sky130_fd_sc_hd__mux2_1
X_5605_ _5685_/CLK _5605_/D fanout315/X VGND VGND VPWR VPWR _5605_/Q sky130_fd_sc_hd__dfrtp_1
X_3866_ _5201_/B _4175_/D _3865_/X VGND VGND VPWR VPWR _3866_/X sky130_fd_sc_hd__o21a_1
X_3797_ _3783_/A _3791_/X _3796_/X VGND VGND VPWR VPWR _4101_/C sky130_fd_sc_hd__a21oi_1
X_2817_ _5754_/Q _2964_/B VGND VGND VPWR VPWR _5067_/B sky130_fd_sc_hd__nor2_1
XANTENNA__4562__A1 _5793_/Q VGND VGND VPWR VPWR sky130_fd_sc_hd__diode_2
XANTENNA_fanout303_A fanout309/X VGND VGND VPWR VPWR sky130_fd_sc_hd__diode_2
X_2748_ _5750_/Q VGND VGND VPWR VPWR _4530_/A sky130_fd_sc_hd__inv_2
X_5536_ _6149_/CLK _5536_/D VGND VGND VPWR VPWR hold47/A sky130_fd_sc_hd__dfxtp_1
X_5467_ _6021_/CLK _5467_/D fanout332/X VGND VGND VPWR VPWR _5467_/Q sky130_fd_sc_hd__dfrtp_4
X_4418_ _4418_/A _4418_/B VGND VGND VPWR VPWR _4418_/Y sky130_fd_sc_hd__nor2_1
Xfanout323 fanout324/X VGND VGND VPWR VPWR fanout323/X sky130_fd_sc_hd__clkbuf_2
X_5398_ _6168_/Q _5427_/B VGND VGND VPWR VPWR _5399_/B sky130_fd_sc_hd__nor2_1
Xfanout312 fanout314/X VGND VGND VPWR VPWR fanout312/X sky130_fd_sc_hd__clkbuf_4
Xfanout301 fanout303/X VGND VGND VPWR VPWR fanout301/X sky130_fd_sc_hd__clkbuf_4
Xfanout345 fanout346/X VGND VGND VPWR VPWR fanout345/X sky130_fd_sc_hd__clkbuf_4
Xfanout334 fanout352/X VGND VGND VPWR VPWR fanout334/X sky130_fd_sc_hd__buf_2
X_4349_ _5187_/B _4349_/B VGND VGND VPWR VPWR _4357_/B sky130_fd_sc_hd__nor2_2
X_6019_ _6091_/CLK _6019_/D fanout347/X VGND VGND VPWR VPWR _6019_/Q sky130_fd_sc_hd__dfrtp_1
XANTENNA__6128__D _6128_/D VGND VGND VPWR VPWR sky130_fd_sc_hd__diode_2
XTAP_TAPCELL_ROW_68_1030 VGND VPWR sky130_fd_sc_hd__tapvpwrvgnd_1
XFILLER_36_23 VGND VGND VPWR VPWR sky130_fd_sc_hd__fill_1
XFILLER_39_281 VPWR VGND VPWR VGND sky130_ef_sc_hd__decap_12
XFILLER_14_104 VPWR VGND VPWR VGND sky130_ef_sc_hd__decap_12
XTAP_TAPCELL_ROW_12_327 VGND VPWR sky130_fd_sc_hd__tapvpwrvgnd_1
XFILLER_23_671 VGND VGND VPWR VPWR sky130_fd_sc_hd__fill_1
XTAP_TAPCELL_ROW_79_1170 VGND VPWR sky130_fd_sc_hd__tapvpwrvgnd_1
XANTENNA__4553__A1 _5761_/Q VGND VGND VPWR VPWR sky130_fd_sc_hd__diode_2
XANTENNA__3761__C1 _3905_/B VGND VGND VPWR VPWR sky130_fd_sc_hd__diode_2
XFILLER_2_531 VGND VGND VPWR VPWR sky130_fd_sc_hd__fill_1
XANTENNA__6158__RESET_B fanout287/X VGND VGND VPWR VPWR sky130_fd_sc_hd__diode_2
XANTENNA__3305__A _5200_/C VGND VGND VPWR VPWR sky130_fd_sc_hd__diode_2
XANTENNA__4835__S _4863_/S VGND VGND VPWR VPWR sky130_fd_sc_hd__diode_2
XFILLER_18_421 VPWR VGND VPWR VGND sky130_ef_sc_hd__decap_12
XFILLER_18_454 VGND VGND VPWR VPWR sky130_fd_sc_hd__decap_3
XFILLER_45_240 VGND VGND VPWR VPWR sky130_fd_sc_hd__fill_1
XFILLER_33_446 VGND VGND VPWR VPWR sky130_fd_sc_hd__fill_2
XANTENNA__5793__RESET_B fanout313/X VGND VGND VPWR VPWR sky130_fd_sc_hd__diode_2
XANTENNA__3044__A1 _4973_/A0 VGND VGND VPWR VPWR sky130_fd_sc_hd__diode_2
XANTENNA__5033__A2 _5043_/A2 VGND VGND VPWR VPWR sky130_fd_sc_hd__diode_2
XFILLER_60_298 VGND VGND VPWR VPWR sky130_fd_sc_hd__fill_1
X_3720_ _3720_/A _3720_/B _3720_/C _3720_/D VGND VGND VPWR VPWR _3720_/Y sky130_fd_sc_hd__nor4_1
XFILLER_14_682 VGND VGND VPWR VPWR sky130_fd_sc_hd__fill_2
Xclkbuf_leaf_40_clk clkload1/A VGND VGND VPWR VPWR _5682_/CLK sky130_fd_sc_hd__clkbuf_8
X_3651_ _6036_/Q _3651_/B VGND VGND VPWR VPWR _3698_/C sky130_fd_sc_hd__and2b_1
XFILLER_61_3 VPWR VGND VPWR VGND sky130_ef_sc_hd__decap_12
X_3582_ _6106_/Q _3647_/A VGND VGND VPWR VPWR _3584_/C sky130_fd_sc_hd__and2b_1
XANTENNA__2878__X _6129_/D VGND VGND VPWR VPWR sky130_fd_sc_hd__diode_2
X_5321_ _5318_/Y _5319_/X _5320_/Y VGND VGND VPWR VPWR _5321_/X sky130_fd_sc_hd__a21o_1
XFILLER_5_391 VGND VGND VPWR VPWR sky130_fd_sc_hd__fill_1
X_5252_ _5244_/A _5244_/B _5244_/C _5342_/C _5342_/B VGND VGND VPWR VPWR _5252_/X
+ sky130_fd_sc_hd__o311a_1
X_4203_ _5788_/Q _4167_/Y _4170_/Y _5780_/Q _4168_/Y VGND VGND VPWR VPWR _4203_/X
+ sky130_fd_sc_hd__a221o_1
X_5183_ _6105_/Q _3639_/A _5185_/S VGND VGND VPWR VPWR _6105_/D sky130_fd_sc_hd__mux2_1
X_4134_ _4247_/A _4255_/C VGND VGND VPWR VPWR _4134_/Y sky130_fd_sc_hd__nor2_1
X_4065_ _3967_/A _4064_/X _4063_/X _4542_/A VGND VGND VPWR VPWR _4065_/X sky130_fd_sc_hd__a211o_1
XANTENNA__3221__Y _3229_/S VGND VGND VPWR VPWR sky130_fd_sc_hd__diode_2
X_3016_ _3014_/X _3015_/X _3953_/B VGND VGND VPWR VPWR _3016_/X sky130_fd_sc_hd__mux2_1
XANTENNA_fanout253_A _5739_/Q VGND VGND VPWR VPWR sky130_fd_sc_hd__diode_2
XANTENNA__5024__A2 _5024_/A2 VGND VGND VPWR VPWR sky130_fd_sc_hd__diode_2
XFILLER_12_608 VGND VGND VPWR VPWR sky130_fd_sc_hd__decap_4
X_4967_ _4967_/A0 _4730_/X _4973_/S VGND VGND VPWR VPWR _4967_/X sky130_fd_sc_hd__mux2_1
X_4898_ _5799_/Q _5523_/Q _4901_/S VGND VGND VPWR VPWR _4898_/X sky130_fd_sc_hd__mux2_1
X_3918_ _5197_/A _3918_/B _3932_/B VGND VGND VPWR VPWR _3918_/X sky130_fd_sc_hd__and3_4
Xclkbuf_leaf_31_clk clkload2/A VGND VGND VPWR VPWR _6113_/CLK sky130_fd_sc_hd__clkbuf_8
XANTENNA__2794__B1 _2918_/B1 VGND VGND VPWR VPWR sky130_fd_sc_hd__diode_2
X_3849_ _5575_/Q _3859_/C _3758_/S VGND VGND VPWR VPWR _3849_/Y sky130_fd_sc_hd__o21ai_1
XANTENNA_fanout306_X fanout306/X VGND VGND VPWR VPWR sky130_fd_sc_hd__diode_2
XANTENNA_clkbuf_2_1__f_clk_X clkbuf_leaf_9_clk/A VGND VGND VPWR VPWR sky130_fd_sc_hd__diode_2
X_5519_ _6115_/CLK _5519_/D fanout329/X VGND VGND VPWR VPWR _5519_/Q sky130_fd_sc_hd__dfrtp_2
XFILLER_3_317 VGND VGND VPWR VPWR sky130_fd_sc_hd__decap_8
Xfanout131 _4809_/S VGND VGND VPWR VPWR _4810_/S sky130_fd_sc_hd__clkbuf_4
Xfanout120 _5067_/X VGND VGND VPWR VPWR _5096_/S sky130_fd_sc_hd__buf_2
Xfanout164 _2972_/Y VGND VGND VPWR VPWR _4751_/S sky130_fd_sc_hd__buf_2
Xfanout142 _4977_/Y VGND VGND VPWR VPWR _5026_/A2 sky130_fd_sc_hd__buf_2
Xfanout153 _2963_/X VGND VGND VPWR VPWR _5189_/A2 sky130_fd_sc_hd__buf_2
XANTENNA__4655__S _4687_/S VGND VGND VPWR VPWR sky130_fd_sc_hd__diode_2
Xfanout175 _2791_/X VGND VGND VPWR VPWR _2918_/B1 sky130_fd_sc_hd__clkbuf_4
Xfanout186 _6176_/Q VGND VGND VPWR VPWR _3905_/A sky130_fd_sc_hd__buf_2
Xfanout197 _6164_/Q VGND VGND VPWR VPWR _5369_/A sky130_fd_sc_hd__buf_2
XTAP_TAPCELL_ROW_45_739 VGND VPWR sky130_fd_sc_hd__tapvpwrvgnd_1
XANTENNA__5015__A2 _5027_/A2 VGND VGND VPWR VPWR sky130_fd_sc_hd__diode_2
XFILLER_42_265 VGND VGND VPWR VPWR sky130_fd_sc_hd__decap_4
XFILLER_42_276 VGND VGND VPWR VPWR sky130_fd_sc_hd__decap_8
Xclkbuf_leaf_22_clk clkload2/A VGND VGND VPWR VPWR _6144_/CLK sky130_fd_sc_hd__clkbuf_8
XTAP_TAPCELL_ROW_25_496 VGND VPWR sky130_fd_sc_hd__tapvpwrvgnd_1
XFILLER_42_298 VGND VGND VPWR VPWR sky130_fd_sc_hd__decap_6
XFILLER_38_505 VGND VGND VPWR VPWR sky130_fd_sc_hd__decap_8
XFILLER_65_335 VGND VGND VPWR VPWR sky130_fd_sc_hd__fill_1
XFILLER_65_324 VGND VGND VPWR VPWR sky130_fd_sc_hd__fill_1
XANTENNA__5903__RESET_B fanout306/X VGND VGND VPWR VPWR sky130_fd_sc_hd__diode_2
XFILLER_34_711 VGND VGND VPWR VPWR sky130_fd_sc_hd__fill_2
XFILLER_80_349 VGND VGND VPWR VPWR sky130_fd_sc_hd__decap_8
X_5870_ _6113_/CLK _5870_/D fanout336/X VGND VGND VPWR VPWR _5870_/Q sky130_fd_sc_hd__dfrtp_1
XANTENNA__5006__A2 _5024_/A2 VGND VGND VPWR VPWR sky130_fd_sc_hd__diode_2
X_4821_ _4522_/A _4823_/A2 _4824_/B1 hold139/X VGND VGND VPWR VPWR _5857_/D sky130_fd_sc_hd__a22o_1
XFILLER_21_405 VGND VGND VPWR VPWR sky130_fd_sc_hd__decap_8
Xclkbuf_leaf_13_clk clkbuf_leaf_9_clk/A VGND VGND VPWR VPWR _3182_/A1 sky130_fd_sc_hd__clkbuf_8
X_4752_ _4226_/S _4751_/X _4750_/X _3877_/S VGND VGND VPWR VPWR _4752_/X sky130_fd_sc_hd__a211o_1
XFILLER_21_449 VGND VGND VPWR VPWR sky130_fd_sc_hd__decap_8
X_4683_ _5959_/Q _4683_/A2 _4683_/B1 _4682_/X VGND VGND VPWR VPWR _4683_/X sky130_fd_sc_hd__a22o_1
X_3703_ _3703_/A _3703_/B VGND VGND VPWR VPWR _3704_/A sky130_fd_sc_hd__nand2_1
X_3634_ _3718_/A _3718_/B _3634_/C _3620_/X VGND VGND VPWR VPWR _3661_/C sky130_fd_sc_hd__or4b_1
X_3565_ _3565_/A _3567_/B VGND VGND VPWR VPWR _5226_/C sky130_fd_sc_hd__nor2_1
XANTENNA__5190__B2 _6109_/Q VGND VGND VPWR VPWR sky130_fd_sc_hd__diode_2
XANTENNA__5190__A1 _2871_/B VGND VGND VPWR VPWR sky130_fd_sc_hd__diode_2
XFILLER_0_309 VPWR VGND VPWR VGND sky130_ef_sc_hd__decap_12
X_5304_ _6153_/Q _5341_/B2 _5327_/C _5303_/Y VGND VGND VPWR VPWR _6153_/D sky130_fd_sc_hd__a22o_1
X_3496_ _3530_/B _3545_/A VGND VGND VPWR VPWR _3563_/C sky130_fd_sc_hd__or2_1
X_5235_ _5235_/A _5235_/B VGND VGND VPWR VPWR _6135_/D sky130_fd_sc_hd__and2_1
X_5166_ hold192/X _5726_/Q _5166_/S VGND VGND VPWR VPWR _6088_/D sky130_fd_sc_hd__mux2_1
XFILLER_29_505 VGND VGND VPWR VPWR sky130_fd_sc_hd__decap_6
XANTENNA__2784__A _2864_/A VGND VGND VPWR VPWR sky130_fd_sc_hd__diode_2
X_5097_ hold134/X _5476_/Q _5097_/S VGND VGND VPWR VPWR _6020_/D sky130_fd_sc_hd__mux2_1
X_4117_ _4116_/B _4116_/C _5575_/Q VGND VGND VPWR VPWR _4117_/Y sky130_fd_sc_hd__a21oi_1
X_4048_ hold52/X _4541_/S _3976_/A VGND VGND VPWR VPWR _4048_/X sky130_fd_sc_hd__a21o_1
XFILLER_44_519 VGND VGND VPWR VPWR sky130_fd_sc_hd__decap_3
XANTENNA_fanout256_X _2934_/B VGND VGND VPWR VPWR sky130_fd_sc_hd__diode_2
XFILLER_24_221 VGND VGND VPWR VPWR sky130_fd_sc_hd__decap_6
XTAP_TAPCELL_ROW_42_709 VGND VPWR sky130_fd_sc_hd__tapvpwrvgnd_1
X_5999_ _6085_/CLK _5999_/D fanout342/X VGND VGND VPWR VPWR _5999_/Q sky130_fd_sc_hd__dfrtp_1
XFILLER_12_405 VGND VGND VPWR VPWR sky130_fd_sc_hd__fill_1
XANTENNA__4756__B2 _3559_/Y VGND VGND VPWR VPWR sky130_fd_sc_hd__diode_2
XFILLER_20_460 VGND VGND VPWR VPWR sky130_fd_sc_hd__decap_4
XTAP_TAPCELL_ROW_22_455 VGND VPWR sky130_fd_sc_hd__tapvpwrvgnd_1
XANTENNA__6141__D _6141_/D VGND VGND VPWR VPWR sky130_fd_sc_hd__diode_2
XANTENNA__5181__A1 _3623_/A VGND VGND VPWR VPWR sky130_fd_sc_hd__diode_2
XFILLER_3_103 VGND VGND VPWR VPWR sky130_fd_sc_hd__fill_1
XFILLER_3_147 VGND VGND VPWR VPWR sky130_fd_sc_hd__fill_1
Xtt_um_bfcpu_359 VGND VGND VPWR VPWR tt_um_bfcpu_359/HI uio_out[4] sky130_fd_sc_hd__conb_1
XANTENNA__4692__B1 _4243_/S VGND VGND VPWR VPWR sky130_fd_sc_hd__diode_2
XANTENNA_fanout71_X _4748_/A2 VGND VGND VPWR VPWR sky130_fd_sc_hd__diode_2
Xhold9 hold9/A VGND VGND VPWR VPWR hold9/X sky130_fd_sc_hd__dlygate4sd3_1
XFILLER_47_368 VGND VGND VPWR VPWR sky130_fd_sc_hd__decap_3
XFILLER_74_97 VPWR VGND VPWR VGND sky130_ef_sc_hd__decap_12
XFILLER_15_232 VGND VGND VPWR VPWR sky130_fd_sc_hd__decap_6
XFILLER_30_213 VGND VGND VPWR VPWR sky130_fd_sc_hd__decap_8
XFILLER_43_563 VPWR VGND VPWR VGND sky130_ef_sc_hd__decap_12
Xhold409 _5941_/Q VGND VGND VPWR VPWR hold409/X sky130_fd_sc_hd__dlygate4sd3_1
XFILLER_7_453 VGND VGND VPWR VPWR sky130_fd_sc_hd__fill_1
XANTENNA__6173__RESET_B fanout286/X VGND VGND VPWR VPWR sky130_fd_sc_hd__diode_2
XANTENNA__5172__A1 _5478_/Q VGND VGND VPWR VPWR sky130_fd_sc_hd__diode_2
X_3350_ _3360_/A _3362_/B _3362_/D _3350_/D VGND VGND VPWR VPWR _3351_/D sky130_fd_sc_hd__or4_1
XFILLER_3_670 VGND VGND VPWR VPWR sky130_fd_sc_hd__fill_2
X_5020_ _4661_/X _4979_/A _4979_/B _4940_/X VGND VGND VPWR VPWR _5020_/X sky130_fd_sc_hd__a22o_1
X_3281_ _3357_/A _3356_/B _3357_/B _3281_/D VGND VGND VPWR VPWR _3282_/D sky130_fd_sc_hd__or4_1
XFILLER_24_3 VPWR VGND VPWR VGND sky130_ef_sc_hd__decap_12
Xclkbuf_leaf_2_clk clkload0/A VGND VGND VPWR VPWR clkload4/A sky130_fd_sc_hd__clkbuf_8
XFILLER_80_113 VGND VGND VPWR VPWR sky130_fd_sc_hd__fill_2
XFILLER_80_124 VGND VGND VPWR VPWR sky130_fd_sc_hd__decap_3
XFILLER_66_699 VGND VGND VPWR VPWR sky130_fd_sc_hd__fill_1
XFILLER_65_198 VPWR VGND VPWR VGND sky130_ef_sc_hd__decap_12
X_5922_ _5963_/CLK _5922_/D fanout307/X VGND VGND VPWR VPWR _5922_/Q sky130_fd_sc_hd__dfrtp_1
X_5853_ _6026_/CLK _5853_/D fanout277/X VGND VGND VPWR VPWR _5853_/Q sky130_fd_sc_hd__dfrtp_1
XANTENNA__4738__A1 _4970_/A0 VGND VGND VPWR VPWR sky130_fd_sc_hd__diode_2
X_5784_ _5792_/CLK _5784_/D fanout296/X VGND VGND VPWR VPWR _5784_/Q sky130_fd_sc_hd__dfrtp_1
X_4804_ _2843_/B hold251/X _4810_/S VGND VGND VPWR VPWR _5841_/D sky130_fd_sc_hd__mux2_1
X_2996_ _4746_/S VGND VGND VPWR VPWR _2996_/Y sky130_fd_sc_hd__inv_2
X_4735_ _5765_/Q _5932_/Q _4735_/S VGND VGND VPWR VPWR _4735_/X sky130_fd_sc_hd__mux2_1
X_4666_ _5472_/Q _5798_/Q _4682_/S VGND VGND VPWR VPWR _4666_/X sky130_fd_sc_hd__mux2_1
XANTENNA__5163__A1 _5473_/Q VGND VGND VPWR VPWR sky130_fd_sc_hd__diode_2
X_4597_ _5948_/Q _5764_/Q _4615_/S VGND VGND VPWR VPWR _4597_/X sky130_fd_sc_hd__mux2_1
X_3617_ _3617_/A _3617_/B _3617_/C _3617_/D VGND VGND VPWR VPWR _3661_/B sky130_fd_sc_hd__or4_1
XANTENNA__4505__A4 _3639_/A VGND VGND VPWR VPWR sky130_fd_sc_hd__diode_2
X_3548_ _3549_/A _3547_/Y _3545_/X VGND VGND VPWR VPWR _3548_/Y sky130_fd_sc_hd__o21ai_4
X_3479_ _4344_/A _3479_/B VGND VGND VPWR VPWR _3479_/X sky130_fd_sc_hd__or2_2
XANTENNA__4674__A0 _5473_/Q VGND VGND VPWR VPWR sky130_fd_sc_hd__diode_2
XTAP_TAPCELL_ROW_71_1070 VGND VPWR sky130_fd_sc_hd__tapvpwrvgnd_1
X_5218_ _5223_/B _5218_/B _5219_/B VGND VGND VPWR VPWR _6124_/D sky130_fd_sc_hd__and3_1
X_5149_ hold243/X _5487_/Q _5172_/S VGND VGND VPWR VPWR _6071_/D sky130_fd_sc_hd__mux2_1
XFILLER_56_121 VGND VGND VPWR VPWR sky130_fd_sc_hd__fill_2
XFILLER_72_603 VGND VGND VPWR VPWR sky130_fd_sc_hd__fill_1
XANTENNA__3229__A1 _5494_/Q VGND VGND VPWR VPWR sky130_fd_sc_hd__diode_2
XFILLER_28_68 VGND VGND VPWR VPWR sky130_fd_sc_hd__fill_1
XTAP_TAPCELL_ROW_27_514 VGND VPWR sky130_fd_sc_hd__tapvpwrvgnd_1
XTAP_TAPCELL_ROW_55_867 VGND VPWR sky130_fd_sc_hd__tapvpwrvgnd_1
XFILLER_25_563 VGND VGND VPWR VPWR sky130_fd_sc_hd__fill_1
XFILLER_12_235 VGND VGND VPWR VPWR sky130_fd_sc_hd__decap_8
XFILLER_40_555 VGND VGND VPWR VPWR sky130_fd_sc_hd__decap_8
XANTENNA__5154__A1 _5492_/Q VGND VGND VPWR VPWR sky130_fd_sc_hd__diode_2
XFILLER_4_401 VGND VGND VPWR VPWR sky130_fd_sc_hd__decap_3
XANTENNA__4901__A1 _5524_/Q VGND VGND VPWR VPWR sky130_fd_sc_hd__diode_2
XFILLER_4_445 VPWR VGND VPWR VGND sky130_ef_sc_hd__decap_12
XANTENNA__2912__B1 _2886_/B VGND VGND VPWR VPWR sky130_fd_sc_hd__diode_2
XTAP_TAPCELL_ROW_7_272 VGND VPWR sky130_fd_sc_hd__tapvpwrvgnd_1
XFILLER_0_673 VPWR VGND VPWR VGND sky130_ef_sc_hd__decap_12
XFILLER_75_441 VGND VGND VPWR VPWR sky130_fd_sc_hd__fill_1
XFILLER_48_699 VGND VGND VPWR VPWR sky130_fd_sc_hd__fill_1
XANTENNA__4843__S _4863_/S VGND VGND VPWR VPWR sky130_fd_sc_hd__diode_2
XANTENNA__2871__B _2871_/B VGND VGND VPWR VPWR sky130_fd_sc_hd__diode_2
X_2850_ _5518_/Q _2831_/Y _2837_/X VGND VGND VPWR VPWR _2850_/X sky130_fd_sc_hd__a21o_1
XPHY_EDGE_ROW_28_Left_109 VGND VGND VPWR VPWR sky130_fd_sc_hd__decap_3
X_2781_ hold221/X input5/X _2781_/S VGND VGND VPWR VPWR _5730_/D sky130_fd_sc_hd__mux2_1
XFILLER_11_290 VPWR VGND VPWR VGND sky130_ef_sc_hd__decap_12
XFILLER_7_250 VPWR VGND VPWR VGND sky130_ef_sc_hd__decap_12
X_4520_ _4520_/A _4520_/B VGND VGND VPWR VPWR _4520_/X sky130_fd_sc_hd__xor2_1
Xhold217 _5822_/Q VGND VGND VPWR VPWR hold217/X sky130_fd_sc_hd__dlygate4sd3_1
XANTENNA__5145__A1 _5521_/Q VGND VGND VPWR VPWR sky130_fd_sc_hd__diode_2
Xhold206 _5786_/Q VGND VGND VPWR VPWR hold206/X sky130_fd_sc_hd__dlygate4sd3_1
X_4451_ _4447_/B _4357_/B _4462_/A _4450_/Y VGND VGND VPWR VPWR _5743_/D sky130_fd_sc_hd__a22o_1
Xhold239 _5821_/Q VGND VGND VPWR VPWR hold239/X sky130_fd_sc_hd__dlygate4sd3_1
XANTENNA__3047__X _6144_/D VGND VGND VPWR VPWR sky130_fd_sc_hd__diode_2
X_3402_ _5094_/A1 _5519_/Q _3407_/S VGND VGND VPWR VPWR _5519_/D sky130_fd_sc_hd__mux2_1
Xhold228 _5815_/Q VGND VGND VPWR VPWR hold228/X sky130_fd_sc_hd__dlygate4sd3_1
X_4382_ _4354_/S _4378_/Y _4381_/X VGND VGND VPWR VPWR _4382_/X sky130_fd_sc_hd__o21a_1
X_6121_ _6161_/CLK _6121_/D fanout311/X VGND VGND VPWR VPWR _6121_/Q sky130_fd_sc_hd__dfrtp_1
X_3333_ _3333_/A _3333_/B VGND VGND VPWR VPWR _3359_/A sky130_fd_sc_hd__or2_1
XPHY_EDGE_ROW_7_Right_7 VGND VGND VPWR VPWR sky130_fd_sc_hd__decap_3
X_6052_ _6061_/CLK _6052_/D fanout283/X VGND VGND VPWR VPWR _6052_/Q sky130_fd_sc_hd__dfrtp_1
X_3264_ _6128_/D _6129_/D VGND VGND VPWR VPWR _3267_/B sky130_fd_sc_hd__or2_1
XPHY_EDGE_ROW_37_Left_118 VGND VGND VPWR VPWR sky130_fd_sc_hd__decap_3
X_5003_ hold406/X _5027_/A2 _5002_/X VGND VGND VPWR VPWR _5947_/D sky130_fd_sc_hd__a21o_1
XFILLER_66_463 VGND VGND VPWR VPWR sky130_fd_sc_hd__fill_1
X_3195_ _5900_/Q _5899_/Q _3399_/C VGND VGND VPWR VPWR _3203_/S sky130_fd_sc_hd__nand3_4
XFILLER_53_113 VPWR VGND VPWR VGND sky130_ef_sc_hd__decap_12
XTAP_TAPCELL_ROW_52_826 VGND VPWR sky130_fd_sc_hd__tapvpwrvgnd_1
X_5905_ _6032_/CLK _5905_/D fanout300/X VGND VGND VPWR VPWR _5905_/Q sky130_fd_sc_hd__dfrtp_1
XPHY_EDGE_ROW_46_Left_127 VGND VGND VPWR VPWR sky130_fd_sc_hd__decap_3
XANTENNA_fanout333_A fanout334/X VGND VGND VPWR VPWR sky130_fd_sc_hd__diode_2
X_5836_ _6093_/CLK _5836_/D fanout345/X VGND VGND VPWR VPWR _5836_/Q sky130_fd_sc_hd__dfrtp_1
X_2979_ _2980_/A _3129_/B VGND VGND VPWR VPWR _2979_/Y sky130_fd_sc_hd__nor2_1
XANTENNA__4187__A2 _4177_/C VGND VGND VPWR VPWR sky130_fd_sc_hd__diode_2
XTAP_TAPCELL_ROW_32_583 VGND VPWR sky130_fd_sc_hd__tapvpwrvgnd_1
XANTENNA__3893__A _5447_/A VGND VGND VPWR VPWR sky130_fd_sc_hd__diode_2
X_5767_ _6163_/CLK _5767_/D fanout325/X VGND VGND VPWR VPWR _5767_/Q sky130_fd_sc_hd__dfrtp_4
X_4718_ _4750_/A1 _4717_/X _4716_/X _4750_/C1 VGND VGND VPWR VPWR _4718_/X sky130_fd_sc_hd__o211a_1
XANTENNA__4592__C1 _4720_/C1 VGND VGND VPWR VPWR sky130_fd_sc_hd__diode_2
XANTENNA__3395__B1 _4544_/A VGND VGND VPWR VPWR sky130_fd_sc_hd__diode_2
X_5698_ _6120_/CLK _5698_/D VGND VGND VPWR VPWR hold66/A sky130_fd_sc_hd__dfxtp_1
X_4649_ hold290/X _4737_/A2 _4648_/X VGND VGND VPWR VPWR _5779_/D sky130_fd_sc_hd__o21a_1
XANTENNA__5136__A1 _3647_/A VGND VGND VPWR VPWR sky130_fd_sc_hd__diode_2
XPHY_EDGE_ROW_55_Left_136 VGND VGND VPWR VPWR sky130_fd_sc_hd__decap_3
XTAP_TAPCELL_ROW_4_231 VGND VPWR sky130_fd_sc_hd__tapvpwrvgnd_1
XFILLER_45_614 VGND VGND VPWR VPWR sky130_fd_sc_hd__fill_2
XPHY_EDGE_ROW_64_Left_145 VGND VGND VPWR VPWR sky130_fd_sc_hd__decap_3
XANTENNA_fanout34_X _4865_/A VGND VGND VPWR VPWR sky130_fd_sc_hd__diode_2
XANTENNA__4178__A2 _4177_/C VGND VGND VPWR VPWR sky130_fd_sc_hd__diode_2
XPHY_EDGE_ROW_73_Left_154 VGND VGND VPWR VPWR sky130_fd_sc_hd__decap_3
XTAP_TAPCELL_ROW_10_299 VGND VPWR sky130_fd_sc_hd__tapvpwrvgnd_1
XANTENNA__3689__A1 _4464_/A VGND VGND VPWR VPWR sky130_fd_sc_hd__diode_2
XFILLER_4_253 VGND VGND VPWR VPWR sky130_fd_sc_hd__decap_6
XANTENNA__4139__A _4164_/B VGND VGND VPWR VPWR sky130_fd_sc_hd__diode_2
XFILLER_48_474 VGND VGND VPWR VPWR sky130_fd_sc_hd__fill_2
XFILLER_63_455 VGND VGND VPWR VPWR sky130_fd_sc_hd__fill_1
X_3951_ _2949_/A _5686_/Q _2948_/Y _3950_/X VGND VGND VPWR VPWR _5608_/D sky130_fd_sc_hd__a31o_1
XANTENNA__4810__A0 _4973_/A0 VGND VGND VPWR VPWR sky130_fd_sc_hd__diode_2
X_2902_ _2833_/A _5094_/A1 _2830_/C _2934_/A VGND VGND VPWR VPWR _2902_/X sky130_fd_sc_hd__a211o_1
XFILLER_16_393 VPWR VGND VPWR VGND sky130_ef_sc_hd__decap_12
XTAP_TAPCELL_ROW_18_399 VGND VPWR sky130_fd_sc_hd__tapvpwrvgnd_1
XFILLER_31_330 VGND VGND VPWR VPWR sky130_fd_sc_hd__decap_6
XFILLER_31_341 VGND VGND VPWR VPWR sky130_fd_sc_hd__fill_1
X_3882_ _3390_/X _3767_/A _3878_/X _3881_/X VGND VGND VPWR VPWR _4118_/B sky130_fd_sc_hd__a211o_1
X_2833_ _2833_/A _2842_/B _5521_/Q _2844_/D VGND VGND VPWR VPWR _2833_/X sky130_fd_sc_hd__or4b_1
X_5621_ _6088_/CLK _5621_/D fanout337/X VGND VGND VPWR VPWR _5621_/Q sky130_fd_sc_hd__dfstp_1
XANTENNA__4574__C1 _4678_/C1 VGND VGND VPWR VPWR sky130_fd_sc_hd__diode_2
X_2764_ _5675_/Q VGND VGND VPWR VPWR _3050_/B sky130_fd_sc_hd__inv_2
X_5552_ _5697_/CLK _5552_/D VGND VGND VPWR VPWR hold64/A sky130_fd_sc_hd__dfxtp_1
X_4503_ _4522_/B _4530_/B VGND VGND VPWR VPWR _4504_/B sky130_fd_sc_hd__or2_1
X_5483_ _6149_/CLK _5483_/D VGND VGND VPWR VPWR hold27/A sky130_fd_sc_hd__dfxtp_1
X_4434_ _3706_/X _4431_/X _4432_/Y _4433_/X VGND VGND VPWR VPWR _4434_/X sky130_fd_sc_hd__a31o_1
X_4365_ _4364_/B _4364_/C _4364_/A VGND VGND VPWR VPWR _4365_/Y sky130_fd_sc_hd__o21ai_1
X_6104_ _6107_/CLK _6104_/D fanout273/X VGND VGND VPWR VPWR _6104_/Q sky130_fd_sc_hd__dfrtp_1
X_3316_ _3349_/C _3343_/B _3360_/B VGND VGND VPWR VPWR _3326_/C sky130_fd_sc_hd__or3_1
X_4296_ _5711_/Q _4308_/A2 _4250_/Y _4295_/X VGND VGND VPWR VPWR _4296_/X sky130_fd_sc_hd__a22o_1
X_6035_ _6106_/CLK _6035_/D fanout275/X VGND VGND VPWR VPWR _6035_/Q sky130_fd_sc_hd__dfrtp_1
XANTENNA_clkbuf_leaf_21_clk_A clkload2/A VGND VGND VPWR VPWR sky130_fd_sc_hd__diode_2
XANTENNA_fanout283_A fanout287/X VGND VGND VPWR VPWR sky130_fd_sc_hd__diode_2
X_3247_ _4350_/A _3248_/B VGND VGND VPWR VPWR _3550_/A sky130_fd_sc_hd__nor2_2
X_3178_ _5716_/Q _3179_/B VGND VGND VPWR VPWR uio_oe[2] sky130_fd_sc_hd__nor2_4
XANTENNA__2792__A _2864_/A VGND VGND VPWR VPWR sky130_fd_sc_hd__diode_2
XTAP_TAPCELL_ROW_37_642 VGND VPWR sky130_fd_sc_hd__tapvpwrvgnd_1
XANTENNA__4801__A0 _5473_/Q VGND VGND VPWR VPWR sky130_fd_sc_hd__diode_2
XTAP_TAPCELL_ROW_65_995 VGND VPWR sky130_fd_sc_hd__tapvpwrvgnd_1
XANTENNA__3604__A1 _4464_/A VGND VGND VPWR VPWR sky130_fd_sc_hd__diode_2
XANTENNA_clkbuf_leaf_36_clk_A clkload1/A VGND VGND VPWR VPWR sky130_fd_sc_hd__diode_2
X_5819_ _6115_/CLK _5819_/D fanout335/X VGND VGND VPWR VPWR _5819_/Q sky130_fd_sc_hd__dfrtp_1
XFILLER_10_503 VGND VGND VPWR VPWR sky130_fd_sc_hd__decap_8
XANTENNA__5109__A1 _6174_/Q VGND VGND VPWR VPWR sky130_fd_sc_hd__diode_2
XFILLER_77_503 VGND VGND VPWR VPWR sky130_fd_sc_hd__fill_1
XFILLER_2_29 VPWR VGND VPWR VGND sky130_ef_sc_hd__decap_12
XANTENNA__4109__D _4865_/A VGND VGND VPWR VPWR sky130_fd_sc_hd__diode_2
XFILLER_17_113 VGND VGND VPWR VPWR sky130_fd_sc_hd__decap_6
XANTENNA__5045__A0 _3651_/B VGND VGND VPWR VPWR sky130_fd_sc_hd__diode_2
XFILLER_17_157 VGND VGND VPWR VPWR sky130_fd_sc_hd__decap_8
XFILLER_33_617 VGND VGND VPWR VPWR sky130_fd_sc_hd__fill_1
XFILLER_60_436 VGND VGND VPWR VPWR sky130_fd_sc_hd__fill_1
XANTENNA__3310__B _5412_/A VGND VGND VPWR VPWR sky130_fd_sc_hd__diode_2
XFILLER_9_334 VGND VGND VPWR VPWR sky130_fd_sc_hd__fill_2
XFILLER_13_374 VGND VGND VPWR VPWR sky130_fd_sc_hd__fill_1
XTAP_TAPCELL_ROW_15_369 VGND VPWR sky130_fd_sc_hd__tapvpwrvgnd_1
XANTENNA__4571__A2 _5055_/S VGND VGND VPWR VPWR sky130_fd_sc_hd__diode_2
XANTENNA__4859__A0 _5094_/A1 VGND VGND VPWR VPWR sky130_fd_sc_hd__diode_2
X_4150_ _4320_/A _4151_/B VGND VGND VPWR VPWR _4150_/Y sky130_fd_sc_hd__nor2_1
X_3101_ _4014_/A _3101_/B VGND VGND VPWR VPWR _3101_/Y sky130_fd_sc_hd__nor2_1
X_4081_ hold96/X _4081_/B VGND VGND VPWR VPWR _5671_/D sky130_fd_sc_hd__xor2_1
X_3032_ _6143_/Q _2965_/X _3027_/X _3031_/X VGND VGND VPWR VPWR _6143_/D sky130_fd_sc_hd__o22a_1
XFILLER_36_433 VGND VGND VPWR VPWR sky130_fd_sc_hd__decap_6
XTAP_TAPCELL_ROW_34_601 VGND VPWR sky130_fd_sc_hd__tapvpwrvgnd_1
XFILLER_36_477 VGND VGND VPWR VPWR sky130_fd_sc_hd__decap_8
X_4983_ hold391/X _5043_/A2 _4982_/X VGND VGND VPWR VPWR _5937_/D sky130_fd_sc_hd__a21o_1
XTAP_TAPCELL_ROW_62_954 VGND VPWR sky130_fd_sc_hd__tapvpwrvgnd_1
XFILLER_16_190 VGND VGND VPWR VPWR sky130_fd_sc_hd__decap_6
X_3934_ _5592_/Q _3554_/Y _3940_/S VGND VGND VPWR VPWR _5592_/D sky130_fd_sc_hd__mux2_1
X_3865_ _4522_/A _4762_/C _3864_/X _3845_/B VGND VGND VPWR VPWR _3865_/X sky130_fd_sc_hd__a211o_1
X_2816_ _5900_/Q _4866_/S _5901_/Q _5719_/Q VGND VGND VPWR VPWR _2816_/X sky130_fd_sc_hd__or4b_1
X_5604_ _5682_/CLK _5604_/D fanout320/X VGND VGND VPWR VPWR _5604_/Q sky130_fd_sc_hd__dfrtp_1
XFILLER_31_171 VGND VGND VPWR VPWR sky130_fd_sc_hd__decap_6
XANTENNA_fanout129_A _4809_/S VGND VGND VPWR VPWR sky130_fd_sc_hd__diode_2
X_3796_ _6167_/Q _3869_/B _3893_/C VGND VGND VPWR VPWR _3796_/X sky130_fd_sc_hd__and3_1
X_2747_ _3639_/A VGND VGND VPWR VPWR _4491_/A sky130_fd_sc_hd__inv_2
X_5535_ _5645_/CLK _5535_/D VGND VGND VPWR VPWR hold67/A sky130_fd_sc_hd__dfxtp_1
X_5466_ _5686_/CLK _5466_/D fanout321/X VGND VGND VPWR VPWR _5466_/Q sky130_fd_sc_hd__dfrtp_2
X_4417_ _5741_/Q _4439_/B _4403_/A _4403_/B _4401_/A VGND VGND VPWR VPWR _4430_/B
+ sky130_fd_sc_hd__a221o_1
XANTENNA__3890__B _3913_/B VGND VGND VPWR VPWR sky130_fd_sc_hd__diode_2
Xfanout302 fanout303/X VGND VGND VPWR VPWR fanout302/X sky130_fd_sc_hd__clkbuf_2
X_5397_ _5397_/A _5427_/B VGND VGND VPWR VPWR _5409_/A sky130_fd_sc_hd__and2_1
Xfanout313 fanout314/X VGND VGND VPWR VPWR fanout313/X sky130_fd_sc_hd__clkbuf_4
Xfanout346 fanout351/X VGND VGND VPWR VPWR fanout346/X sky130_fd_sc_hd__dlymetal6s2s_1
XANTENNA_input3_A uio_in[2] VGND VGND VPWR VPWR sky130_fd_sc_hd__diode_2
X_4348_ _4539_/A _4349_/B VGND VGND VPWR VPWR _4475_/B sky130_fd_sc_hd__nor2_4
Xfanout324 input1/X VGND VGND VPWR VPWR fanout324/X sky130_fd_sc_hd__clkbuf_2
Xfanout335 fanout336/X VGND VGND VPWR VPWR fanout335/X sky130_fd_sc_hd__clkbuf_4
X_4279_ _4200_/X _4278_/X _5458_/C VGND VGND VPWR VPWR _4279_/X sky130_fd_sc_hd__mux2_1
XANTENNA_fanout286_X fanout286/X VGND VGND VPWR VPWR sky130_fd_sc_hd__diode_2
X_6018_ _6094_/CLK _6018_/D fanout348/X VGND VGND VPWR VPWR _6018_/Q sky130_fd_sc_hd__dfrtp_1
XTAP_TAPCELL_ROW_68_1031 VGND VPWR sky130_fd_sc_hd__tapvpwrvgnd_1
XFILLER_15_617 VGND VGND VPWR VPWR sky130_fd_sc_hd__fill_2
XANTENNA__5102__S _5127_/B VGND VGND VPWR VPWR sky130_fd_sc_hd__diode_2
XFILLER_14_116 VGND VGND VPWR VPWR sky130_fd_sc_hd__decap_6
XANTENNA__6144__D _6144_/D VGND VGND VPWR VPWR sky130_fd_sc_hd__diode_2
XFILLER_14_138 VGND VGND VPWR VPWR sky130_fd_sc_hd__fill_2
XFILLER_30_609 VGND VGND VPWR VPWR sky130_fd_sc_hd__decap_6
XANTENNA__2800__A2 _2917_/A2 VGND VGND VPWR VPWR sky130_fd_sc_hd__diode_2
XTAP_TAPCELL_ROW_12_328 VGND VPWR sky130_fd_sc_hd__tapvpwrvgnd_1
XTAP_TAPCELL_ROW_79_1171 VGND VPWR sky130_fd_sc_hd__tapvpwrvgnd_1
XANTENNA__2867__A2 _2783_/B VGND VGND VPWR VPWR sky130_fd_sc_hd__diode_2
XFILLER_2_587 VGND VGND VPWR VPWR sky130_fd_sc_hd__fill_1
XFILLER_38_709 VGND VGND VPWR VPWR sky130_fd_sc_hd__decap_4
XFILLER_37_219 VGND VGND VPWR VPWR sky130_fd_sc_hd__fill_1
XFILLER_18_433 VGND VGND VPWR VPWR sky130_fd_sc_hd__fill_2
XANTENNA__3816__A1 _4447_/B VGND VGND VPWR VPWR sky130_fd_sc_hd__diode_2
XANTENNA__5018__B1 _5026_/B1 VGND VGND VPWR VPWR sky130_fd_sc_hd__diode_2
XFILLER_60_200 VGND VGND VPWR VPWR sky130_fd_sc_hd__decap_4
XANTENNA__4851__S _4855_/S VGND VGND VPWR VPWR sky130_fd_sc_hd__diode_2
XFILLER_60_255 VGND VGND VPWR VPWR sky130_fd_sc_hd__fill_1
XANTENNA__4241__A1 _5767_/Q VGND VGND VPWR VPWR sky130_fd_sc_hd__diode_2
X_3650_ _3651_/B _6036_/Q VGND VGND VPWR VPWR _3653_/B sky130_fd_sc_hd__and2b_1
X_3581_ _6108_/Q _4530_/A VGND VGND VPWR VPWR _3584_/B sky130_fd_sc_hd__nor2_1
XFILLER_9_197 VPWR VGND VPWR VGND sky130_ef_sc_hd__decap_12
XFILLER_54_3 VPWR VGND VPWR VGND sky130_ef_sc_hd__decap_12
X_5320_ _5318_/Y _5319_/X _5327_/C VGND VGND VPWR VPWR _5320_/Y sky130_fd_sc_hd__o21ai_1
X_5251_ _5197_/B _4350_/X _5196_/B _4344_/A VGND VGND VPWR VPWR _5342_/C sky130_fd_sc_hd__a31o_1
X_4202_ _5939_/Q _5763_/Q _4232_/S VGND VGND VPWR VPWR _4202_/X sky130_fd_sc_hd__mux2_1
XFILLER_68_300 VGND VGND VPWR VPWR sky130_fd_sc_hd__fill_1
XANTENNA__2858__A2 _2910_/B VGND VGND VPWR VPWR sky130_fd_sc_hd__diode_2
X_5182_ hold334/X _3626_/A _5185_/S VGND VGND VPWR VPWR _6104_/D sky130_fd_sc_hd__mux2_1
X_4133_ _4331_/A1 _4319_/A _4329_/B VGND VGND VPWR VPWR _4133_/X sky130_fd_sc_hd__a21o_1
X_4064_ hold65/A hold56/A _4070_/S VGND VGND VPWR VPWR _4064_/X sky130_fd_sc_hd__mux2_1
X_3015_ hold75/A hold20/A hold53/A hold72/A _3954_/A _3955_/A VGND VGND VPWR VPWR
+ _3015_/X sky130_fd_sc_hd__mux4_1
XFILLER_52_712 VGND VGND VPWR VPWR sky130_fd_sc_hd__fill_1
XFILLER_36_230 VGND VGND VPWR VPWR sky130_fd_sc_hd__decap_4
XTAP_TAPCELL_ROW_47_770 VGND VPWR sky130_fd_sc_hd__tapvpwrvgnd_1
X_4966_ hold461/X _4972_/A2 _4965_/X VGND VGND VPWR VPWR _5931_/D sky130_fd_sc_hd__a21o_1
XANTENNA__4232__A1 _5766_/Q VGND VGND VPWR VPWR sky130_fd_sc_hd__diode_2
XANTENNA_fanout246_A _4427_/A VGND VGND VPWR VPWR sky130_fd_sc_hd__diode_2
X_3917_ _5581_/Q _3916_/X _3917_/S VGND VGND VPWR VPWR _5581_/D sky130_fd_sc_hd__mux2_1
X_4897_ _5908_/Q _4975_/A2 _4896_/X VGND VGND VPWR VPWR _5908_/D sky130_fd_sc_hd__a21o_1
XFILLER_22_15 VGND VGND VPWR VPWR sky130_fd_sc_hd__decap_4
X_3848_ _4116_/B _4116_/C _3773_/A VGND VGND VPWR VPWR _3848_/Y sky130_fd_sc_hd__a21oi_1
X_3779_ _5200_/C _3902_/A2 _3783_/B VGND VGND VPWR VPWR _3779_/X sky130_fd_sc_hd__o21a_1
XANTENNA_fanout201_X _2895_/A VGND VGND VPWR VPWR sky130_fd_sc_hd__diode_2
X_5518_ _6115_/CLK _5518_/D fanout329/X VGND VGND VPWR VPWR _5518_/Q sky130_fd_sc_hd__dfrtp_2
X_5449_ _6175_/Q _5453_/B VGND VGND VPWR VPWR _5450_/B sky130_fd_sc_hd__or2_1
XFILLER_78_119 VPWR VGND VPWR VGND sky130_ef_sc_hd__decap_12
Xfanout121 _5038_/B1 VGND VGND VPWR VPWR _4979_/B sky130_fd_sc_hd__clkbuf_4
XANTENNA__2849__A2 _5522_/Q VGND VGND VPWR VPWR sky130_fd_sc_hd__diode_2
Xfanout110 _4864_/S VGND VGND VPWR VPWR _4862_/S sky130_fd_sc_hd__clkbuf_4
XANTENNA__4001__S _4005_/S VGND VGND VPWR VPWR sky130_fd_sc_hd__diode_2
Xfanout165 _2970_/X VGND VGND VPWR VPWR _4687_/S sky130_fd_sc_hd__clkbuf_4
Xfanout132 _4778_/Y VGND VGND VPWR VPWR _4809_/S sky130_fd_sc_hd__clkbuf_2
Xfanout154 _3240_/A VGND VGND VPWR VPWR _2837_/B sky130_fd_sc_hd__buf_2
Xfanout143 _4876_/Y VGND VGND VPWR VPWR _4878_/A sky130_fd_sc_hd__clkbuf_4
Xfanout176 _2791_/X VGND VGND VPWR VPWR _2927_/B1 sky130_fd_sc_hd__clkbuf_2
XFILLER_59_377 VGND VGND VPWR VPWR sky130_fd_sc_hd__fill_2
Xfanout198 _6132_/Q VGND VGND VPWR VPWR _3530_/A sky130_fd_sc_hd__clkbuf_4
Xfanout187 _6175_/Q VGND VGND VPWR VPWR _5447_/A sky130_fd_sc_hd__buf_2
XANTENNA__2964__B _2964_/B VGND VGND VPWR VPWR sky130_fd_sc_hd__diode_2
XANTENNA__4671__S _4687_/S VGND VGND VPWR VPWR sky130_fd_sc_hd__diode_2
XANTENNA__4223__A1 _5765_/Q VGND VGND VPWR VPWR sky130_fd_sc_hd__diode_2
XFILLER_30_417 VGND VGND VPWR VPWR sky130_fd_sc_hd__decap_3
XTAP_TAPCELL_ROW_25_497 VGND VPWR sky130_fd_sc_hd__tapvpwrvgnd_1
XFILLER_10_141 VPWR VGND VPWR VGND sky130_ef_sc_hd__decap_12
XFILLER_7_657 VGND VGND VPWR VPWR sky130_fd_sc_hd__fill_1
XFILLER_6_145 VGND VGND VPWR VPWR sky130_fd_sc_hd__fill_1
XFILLER_6_189 VGND VGND VPWR VPWR sky130_fd_sc_hd__decap_6
XFILLER_26_7 VGND VGND VPWR VPWR sky130_fd_sc_hd__fill_1
XFILLER_18_241 VGND VGND VPWR VPWR sky130_fd_sc_hd__decap_4
XANTENNA__5943__RESET_B fanout303/X VGND VGND VPWR VPWR sky130_fd_sc_hd__diode_2
X_4820_ _3626_/A _4823_/A2 _4824_/B1 hold107/X VGND VGND VPWR VPWR _5856_/D sky130_fd_sc_hd__a22o_1
XANTENNA__4214__A1 _5764_/Q VGND VGND VPWR VPWR sky130_fd_sc_hd__diode_2
X_4751_ _5767_/Q _5934_/Q _4751_/S VGND VGND VPWR VPWR _4751_/X sky130_fd_sc_hd__mux2_1
XANTENNA__3197__S _3203_/S VGND VGND VPWR VPWR sky130_fd_sc_hd__diode_2
X_4682_ _5474_/Q _5800_/Q _4682_/S VGND VGND VPWR VPWR _4682_/X sky130_fd_sc_hd__mux2_1
X_3702_ _3713_/A _3687_/X _3693_/X _3701_/X VGND VGND VPWR VPWR _3703_/B sky130_fd_sc_hd__o31a_1
X_3633_ _3633_/A _3718_/C _3633_/C _3632_/X VGND VGND VPWR VPWR _3634_/C sky130_fd_sc_hd__or4b_1
X_3564_ _3564_/A _3564_/B _3563_/B VGND VGND VPWR VPWR _5207_/B sky130_fd_sc_hd__or3b_1
X_5303_ _5303_/A _5303_/B VGND VGND VPWR VPWR _5303_/Y sky130_fd_sc_hd__nor2_1
X_3495_ _3495_/A _3495_/B VGND VGND VPWR VPWR _3537_/A sky130_fd_sc_hd__or2_1
X_5234_ hold348/X _5362_/B _5233_/X VGND VGND VPWR VPWR _6134_/D sky130_fd_sc_hd__a21o_1
X_5165_ hold200/X _5725_/Q _5167_/S VGND VGND VPWR VPWR _6087_/D sky130_fd_sc_hd__mux2_1
XFILLER_68_141 VGND VGND VPWR VPWR sky130_fd_sc_hd__decap_6
XANTENNA__5441__A _6174_/Q VGND VGND VPWR VPWR sky130_fd_sc_hd__diode_2
XANTENNA_fanout196_A _5369_/A VGND VGND VPWR VPWR sky130_fd_sc_hd__diode_2
X_4116_ _5575_/Q _4116_/B _4116_/C VGND VGND VPWR VPWR _4116_/X sky130_fd_sc_hd__and3_1
X_5096_ hold115/X _5475_/Q _5096_/S VGND VGND VPWR VPWR _6019_/D sky130_fd_sc_hd__mux2_1
XANTENNA__2784__B _2871_/B VGND VGND VPWR VPWR sky130_fd_sc_hd__diode_2
X_4047_ _4074_/S1 _4046_/X _4045_/X _4542_/A VGND VGND VPWR VPWR _4047_/X sky130_fd_sc_hd__a211o_1
X_5998_ _6094_/CLK _5998_/D fanout348/X VGND VGND VPWR VPWR _5998_/Q sky130_fd_sc_hd__dfrtp_1
XANTENNA__4205__A1 _5763_/Q VGND VGND VPWR VPWR sky130_fd_sc_hd__diode_2
XANTENNA_fanout249_X _3651_/B VGND VGND VPWR VPWR sky130_fd_sc_hd__diode_2
X_4949_ _5474_/Q _4682_/X _4949_/S VGND VGND VPWR VPWR _4949_/X sky130_fd_sc_hd__mux2_1
XTAP_TAPCELL_ROW_22_456 VGND VPWR sky130_fd_sc_hd__tapvpwrvgnd_1
XTAP_TAPCELL_ROW_76_1130 VGND VPWR sky130_fd_sc_hd__tapvpwrvgnd_1
XFILLER_59_185 VGND VGND VPWR VPWR sky130_fd_sc_hd__fill_2
XANTENNA__4995__A2 _5043_/A2 VGND VGND VPWR VPWR sky130_fd_sc_hd__diode_2
XANTENNA__4747__A2 _4747_/A2 VGND VGND VPWR VPWR sky130_fd_sc_hd__diode_2
X_3280_ _3355_/A _3355_/B _3280_/C _3355_/C VGND VGND VPWR VPWR _3281_/D sky130_fd_sc_hd__or4_1
XFILLER_65_111 VGND VGND VPWR VPWR sky130_fd_sc_hd__fill_1
XFILLER_17_3 VGND VGND VPWR VPWR sky130_fd_sc_hd__decap_4
X_5921_ _6097_/CLK _5921_/D fanout326/X VGND VGND VPWR VPWR _5921_/Q sky130_fd_sc_hd__dfrtp_1
XFILLER_80_136 VGND VGND VPWR VPWR sky130_fd_sc_hd__decap_4
XANTENNA__4986__A2 _5026_/A2 VGND VGND VPWR VPWR sky130_fd_sc_hd__diode_2
XFILLER_34_520 VGND VGND VPWR VPWR sky130_fd_sc_hd__fill_1
XFILLER_34_531 VGND VGND VPWR VPWR sky130_fd_sc_hd__fill_1
X_5852_ _6026_/CLK _5852_/D fanout277/X VGND VGND VPWR VPWR _5852_/Q sky130_fd_sc_hd__dfrtp_1
XFILLER_34_586 VGND VGND VPWR VPWR sky130_fd_sc_hd__fill_2
X_4803_ _2824_/C hold210/X _4807_/S VGND VGND VPWR VPWR _5840_/D sky130_fd_sc_hd__mux2_1
X_5783_ _5966_/CLK _5783_/D fanout304/X VGND VGND VPWR VPWR _5783_/Q sky130_fd_sc_hd__dfrtp_1
X_4734_ _4750_/A1 _4733_/X _4732_/X _4750_/C1 VGND VGND VPWR VPWR _4734_/X sky130_fd_sc_hd__o211a_1
X_2995_ _3150_/B _3150_/C VGND VGND VPWR VPWR _4746_/S sky130_fd_sc_hd__nand2_4
X_4665_ hold291/X _4745_/A2 _4664_/X VGND VGND VPWR VPWR _5781_/D sky130_fd_sc_hd__o21a_1
X_4596_ _5948_/Q _4683_/A2 _4740_/B1 _4595_/X VGND VGND VPWR VPWR _4596_/X sky130_fd_sc_hd__a211o_1
XANTENNA_fanout111_A _4855_/S VGND VGND VPWR VPWR sky130_fd_sc_hd__diode_2
X_3616_ _5750_/Q _2749_/Y _3613_/Y _3715_/C _3615_/X VGND VGND VPWR VPWR _3617_/D
+ sky130_fd_sc_hd__a2111o_1
X_3547_ _3547_/A _3547_/B VGND VGND VPWR VPWR _3547_/Y sky130_fd_sc_hd__xnor2_2
X_3478_ _4344_/A _3479_/B VGND VGND VPWR VPWR _3478_/Y sky130_fd_sc_hd__nor2_1
XANTENNA__4674__A1 _5799_/Q VGND VGND VPWR VPWR sky130_fd_sc_hd__diode_2
XTAP_TAPCELL_ROW_71_1071 VGND VPWR sky130_fd_sc_hd__tapvpwrvgnd_1
X_6197_ _6197_/A VGND VGND VPWR VPWR uo_out[0] sky130_fd_sc_hd__buf_4
X_5217_ _5217_/A _5217_/B VGND VGND VPWR VPWR _5219_/B sky130_fd_sc_hd__nand2_1
X_5148_ hold201/X _5524_/Q _5172_/S VGND VGND VPWR VPWR _6070_/D sky130_fd_sc_hd__mux2_1
X_5079_ hold233/X _5490_/Q _5099_/S VGND VGND VPWR VPWR _6002_/D sky130_fd_sc_hd__mux2_1
XTAP_TAPCELL_ROW_27_515 VGND VPWR sky130_fd_sc_hd__tapvpwrvgnd_1
XTAP_TAPCELL_ROW_55_868 VGND VPWR sky130_fd_sc_hd__tapvpwrvgnd_1
XANTENNA__5110__S _5127_/B VGND VGND VPWR VPWR sky130_fd_sc_hd__diode_2
XFILLER_12_247 VGND VGND VPWR VPWR sky130_fd_sc_hd__decap_4
XFILLER_4_457 VGND VGND VPWR VPWR sky130_fd_sc_hd__decap_3
XFILLER_79_214 VGND VGND VPWR VPWR sky130_fd_sc_hd__fill_1
XFILLER_48_601 VGND VGND VPWR VPWR sky130_fd_sc_hd__decap_8
XTAP_TAPCELL_ROW_7_273 VGND VPWR sky130_fd_sc_hd__tapvpwrvgnd_1
XTAP_TAPCELL_ROW_7_262 VGND VPWR sky130_fd_sc_hd__tapvpwrvgnd_1
XFILLER_0_641 VGND VGND VPWR VPWR sky130_fd_sc_hd__decap_3
XFILLER_0_685 VPWR VGND VPWR VGND sky130_ef_sc_hd__decap_12
XFILLER_75_486 VGND VGND VPWR VPWR sky130_fd_sc_hd__fill_1
XFILLER_63_615 VGND VGND VPWR VPWR sky130_fd_sc_hd__fill_1
XFILLER_47_177 VGND VGND VPWR VPWR sky130_fd_sc_hd__fill_1
XANTENNA__5090__A1 _5473_/Q VGND VGND VPWR VPWR sky130_fd_sc_hd__diode_2
XANTENNA__4968__A2 _4878_/A VGND VGND VPWR VPWR sky130_fd_sc_hd__diode_2
XANTENNA__2871__C _2871_/C VGND VGND VPWR VPWR sky130_fd_sc_hd__diode_2
XFILLER_31_501 VGND VGND VPWR VPWR sky130_fd_sc_hd__decap_3
XFILLER_70_191 VGND VGND VPWR VPWR sky130_fd_sc_hd__decap_3
X_2780_ hold144/X input6/X _2781_/S VGND VGND VPWR VPWR _5731_/D sky130_fd_sc_hd__mux2_1
Xhold207 _6075_/Q VGND VGND VPWR VPWR hold207/X sky130_fd_sc_hd__dlygate4sd3_1
X_4450_ _4443_/Y _4446_/X _4449_/X VGND VGND VPWR VPWR _4450_/Y sky130_fd_sc_hd__o21ai_1
Xhold229 _6094_/Q VGND VGND VPWR VPWR hold229/X sky130_fd_sc_hd__dlygate4sd3_1
Xhold218 _6007_/Q VGND VGND VPWR VPWR hold218/X sky130_fd_sc_hd__dlygate4sd3_1
X_3401_ _2843_/B _5518_/Q _3407_/S VGND VGND VPWR VPWR _5518_/D sky130_fd_sc_hd__mux2_1
X_4381_ _4394_/B _4380_/Y _3479_/X VGND VGND VPWR VPWR _4381_/X sky130_fd_sc_hd__a21o_1
XANTENNA__2903__B2 _5469_/Q VGND VGND VPWR VPWR sky130_fd_sc_hd__diode_2
XANTENNA__2903__A1 _5473_/Q VGND VGND VPWR VPWR sky130_fd_sc_hd__diode_2
X_6120_ _6120_/CLK _6120_/D fanout313/X VGND VGND VPWR VPWR _6120_/Q sky130_fd_sc_hd__dfrtp_1
X_3332_ _3356_/A _3357_/B _3357_/D _3332_/D VGND VGND VPWR VPWR _3335_/B sky130_fd_sc_hd__or4_1
X_6051_ _6159_/CLK _6051_/D fanout282/X VGND VGND VPWR VPWR _6051_/Q sky130_fd_sc_hd__dfrtp_1
XANTENNA__3654__A_N _4444_/B VGND VGND VPWR VPWR sky130_fd_sc_hd__diode_2
X_3263_ _3930_/C _3480_/B VGND VGND VPWR VPWR _5231_/A sky130_fd_sc_hd__nor2_1
X_5002_ _4589_/X _5024_/A2 _5024_/B1 _4913_/X VGND VGND VPWR VPWR _5002_/X sky130_fd_sc_hd__a22o_1
X_3194_ _5900_/Q _4866_/S VGND VGND VPWR VPWR _4167_/B sky130_fd_sc_hd__nand2_1
XFILLER_66_475 VGND VGND VPWR VPWR sky130_fd_sc_hd__fill_1
XFILLER_26_306 VGND VGND VPWR VPWR sky130_fd_sc_hd__fill_2
XFILLER_53_125 VGND VGND VPWR VPWR sky130_fd_sc_hd__decap_6
XANTENNA__4959__A2 _4878_/A VGND VGND VPWR VPWR sky130_fd_sc_hd__diode_2
XFILLER_19_391 VGND VGND VPWR VPWR sky130_fd_sc_hd__fill_1
XANTENNA__5081__A1 _5492_/Q VGND VGND VPWR VPWR sky130_fd_sc_hd__diode_2
X_5904_ _5965_/CLK _5904_/D fanout302/X VGND VGND VPWR VPWR _5904_/Q sky130_fd_sc_hd__dfrtp_1
XTAP_TAPCELL_ROW_52_827 VGND VPWR sky130_fd_sc_hd__tapvpwrvgnd_1
X_5835_ _6094_/CLK _5835_/D fanout350/X VGND VGND VPWR VPWR _5835_/Q sky130_fd_sc_hd__dfrtp_1
XANTENNA_fanout159_A _4674_/S VGND VGND VPWR VPWR sky130_fd_sc_hd__diode_2
XANTENNA__3919__B1 _3549_/Y VGND VGND VPWR VPWR sky130_fd_sc_hd__diode_2
XANTENNA_fanout326_A fanout352/X VGND VGND VPWR VPWR sky130_fd_sc_hd__diode_2
X_2978_ _4977_/A _4687_/S VGND VGND VPWR VPWR _2978_/Y sky130_fd_sc_hd__nand2_2
XANTENNA__4041__C1 _4542_/A VGND VGND VPWR VPWR sky130_fd_sc_hd__diode_2
XTAP_TAPCELL_ROW_32_584 VGND VPWR sky130_fd_sc_hd__tapvpwrvgnd_1
XANTENNA__3893__B _3905_/B VGND VGND VPWR VPWR sky130_fd_sc_hd__diode_2
X_5766_ _6163_/CLK _5766_/D fanout325/X VGND VGND VPWR VPWR _5766_/Q sky130_fd_sc_hd__dfrtp_4
X_4717_ _5763_/Q _5963_/Q _4735_/S VGND VGND VPWR VPWR _4717_/X sky130_fd_sc_hd__mux2_1
X_5697_ _5697_/CLK _5697_/D VGND VGND VPWR VPWR hold62/A sky130_fd_sc_hd__dfxtp_1
X_4648_ _4644_/X _4646_/X _4647_/X _4672_/A1 _4704_/C1 VGND VGND VPWR VPWR _4648_/X
+ sky130_fd_sc_hd__a221o_1
XANTENNA__6064__RESET_B fanout341/X VGND VGND VPWR VPWR sky130_fd_sc_hd__diode_2
XANTENNA__4895__A1 _5522_/Q VGND VGND VPWR VPWR sky130_fd_sc_hd__diode_2
X_4579_ _5913_/Q _4684_/A2 _4667_/B1 _4578_/X VGND VGND VPWR VPWR _4579_/X sky130_fd_sc_hd__a22o_1
XFILLER_1_405 VPWR VGND VPWR VGND sky130_ef_sc_hd__decap_12
XFILLER_1_449 VPWR VGND VPWR VGND sky130_ef_sc_hd__decap_12
XANTENNA__4647__A1 _5762_/Q VGND VGND VPWR VPWR sky130_fd_sc_hd__diode_2
XTAP_TAPCELL_ROW_4_232 VGND VPWR sky130_fd_sc_hd__tapvpwrvgnd_1
XFILLER_39_68 VGND VGND VPWR VPWR sky130_fd_sc_hd__fill_1
XANTENNA__5105__S _5109_/S VGND VGND VPWR VPWR sky130_fd_sc_hd__diode_2
XFILLER_57_497 VGND VGND VPWR VPWR sky130_fd_sc_hd__fill_1
XFILLER_55_23 VGND VGND VPWR VPWR sky130_fd_sc_hd__fill_2
XFILLER_17_317 VGND VGND VPWR VPWR sky130_fd_sc_hd__fill_2
XFILLER_72_434 VGND VGND VPWR VPWR sky130_fd_sc_hd__fill_1
XANTENNA__5072__A1 _5521_/Q VGND VGND VPWR VPWR sky130_fd_sc_hd__diode_2
XFILLER_29_199 VGND VGND VPWR VPWR sky130_fd_sc_hd__fill_1
XFILLER_9_549 VGND VGND VPWR VPWR sky130_fd_sc_hd__decap_8
XANTENNA__4335__A0 _5094_/A1 VGND VGND VPWR VPWR sky130_fd_sc_hd__diode_2
XANTENNA__2897__B1 _2918_/B1 VGND VGND VPWR VPWR sky130_fd_sc_hd__diode_2
XFILLER_4_287 VPWR VGND VPWR VGND sky130_ef_sc_hd__decap_12
XANTENNA__4638__A1 _4750_/A1 VGND VGND VPWR VPWR sky130_fd_sc_hd__diode_2
Xhold90 hold90/A VGND VGND VPWR VPWR hold90/X sky130_fd_sc_hd__dlygate4sd3_1
XANTENNA__5063__A1 _5201_/B VGND VGND VPWR VPWR sky130_fd_sc_hd__diode_2
XFILLER_50_106 VGND VGND VPWR VPWR sky130_fd_sc_hd__decap_4
X_3950_ _5686_/Q _5608_/Q VGND VGND VPWR VPWR _3950_/X sky130_fd_sc_hd__and2b_1
X_2901_ _2901_/A _2901_/B _2901_/C _2901_/D VGND VGND VPWR VPWR _2901_/X sky130_fd_sc_hd__or4_1
XFILLER_50_139 VGND VGND VPWR VPWR sky130_fd_sc_hd__fill_1
X_3881_ _4109_/C _4865_/A _3879_/X _3880_/X VGND VGND VPWR VPWR _3881_/X sky130_fd_sc_hd__a31o_1
X_2832_ _2834_/C _5487_/Q _2844_/C _2844_/D VGND VGND VPWR VPWR _2832_/X sky130_fd_sc_hd__a211o_1
X_5620_ _6113_/CLK _5620_/D fanout337/X VGND VGND VPWR VPWR _5620_/Q sky130_fd_sc_hd__dfrtp_1
X_2763_ _5721_/Q VGND VGND VPWR VPWR _4093_/A sky130_fd_sc_hd__inv_2
X_5551_ _5696_/CLK _5551_/D VGND VGND VPWR VPWR hold31/A sky130_fd_sc_hd__dfxtp_1
X_4502_ _4522_/B _4530_/B VGND VGND VPWR VPWR _4504_/A sky130_fd_sc_hd__nand2_1
XFILLER_6_61 VGND VGND VPWR VPWR sky130_fd_sc_hd__fill_1
X_5482_ _5645_/CLK _5482_/D VGND VGND VPWR VPWR hold43/A sky130_fd_sc_hd__dfxtp_1
XFILLER_6_94 VPWR VGND VPWR VGND sky130_ef_sc_hd__decap_12
X_4433_ _4429_/Y _4430_/X _3706_/X VGND VGND VPWR VPWR _4433_/X sky130_fd_sc_hd__o21ba_1
XANTENNA__2888__B1 _2918_/B1 VGND VGND VPWR VPWR sky130_fd_sc_hd__diode_2
X_4364_ _4364_/A _4364_/B _4364_/C VGND VGND VPWR VPWR _4364_/X sky130_fd_sc_hd__or3_1
X_4295_ _5571_/Q _5579_/Q _4307_/S VGND VGND VPWR VPWR _4295_/X sky130_fd_sc_hd__mux2_1
X_6103_ _6107_/CLK _6103_/D fanout273/X VGND VGND VPWR VPWR _6103_/Q sky130_fd_sc_hd__dfrtp_1
X_3315_ _5982_/Q _5397_/A VGND VGND VPWR VPWR _3360_/B sky130_fd_sc_hd__and2b_1
XANTENNA__4629__A1 _5760_/Q VGND VGND VPWR VPWR sky130_fd_sc_hd__diode_2
X_3246_ _6135_/Q _6134_/Q _6136_/Q _6133_/Q VGND VGND VPWR VPWR _3248_/B sky130_fd_sc_hd__or4bb_2
X_6034_ clkload5/A _6034_/D fanout280/X VGND VGND VPWR VPWR _6034_/Q sky130_fd_sc_hd__dfrtp_1
X_3177_ _5717_/Q _3179_/B VGND VGND VPWR VPWR uio_oe[3] sky130_fd_sc_hd__nor2_4
XANTENNA_fanout276_A fanout287/X VGND VGND VPWR VPWR sky130_fd_sc_hd__diode_2
XFILLER_27_626 VPWR VGND VPWR VGND sky130_ef_sc_hd__decap_12
XANTENNA__2792__B _2871_/C VGND VGND VPWR VPWR sky130_fd_sc_hd__diode_2
XPHY_EDGE_ROW_16_Left_97 VGND VGND VPWR VPWR sky130_fd_sc_hd__decap_3
XTAP_TAPCELL_ROW_37_643 VGND VPWR sky130_fd_sc_hd__tapvpwrvgnd_1
XTAP_TAPCELL_ROW_65_996 VGND VPWR sky130_fd_sc_hd__tapvpwrvgnd_1
XANTENNA__2812__B1 _2918_/B1 VGND VGND VPWR VPWR sky130_fd_sc_hd__diode_2
X_5818_ _6115_/CLK _5818_/D fanout336/X VGND VGND VPWR VPWR _5818_/Q sky130_fd_sc_hd__dfrtp_1
XFILLER_6_508 VGND VGND VPWR VPWR sky130_fd_sc_hd__fill_1
X_5749_ clkload6/A _5749_/D fanout284/X VGND VGND VPWR VPWR _5749_/Q sky130_fd_sc_hd__dfrtp_1
XANTENNA__4004__S _4005_/S VGND VGND VPWR VPWR sky130_fd_sc_hd__diode_2
XANTENNA__4868__A1 _4865_/A VGND VGND VPWR VPWR sky130_fd_sc_hd__diode_2
XANTENNA__2879__B1 _2918_/B1 VGND VGND VPWR VPWR sky130_fd_sc_hd__diode_2
XFILLER_1_279 VGND VGND VPWR VPWR sky130_fd_sc_hd__fill_1
XFILLER_77_559 VGND VGND VPWR VPWR sky130_fd_sc_hd__fill_1
XANTENNA__4096__A2 _3913_/B VGND VGND VPWR VPWR sky130_fd_sc_hd__diode_2
XANTENNA__4674__S _4674_/S VGND VGND VPWR VPWR sky130_fd_sc_hd__diode_2
XFILLER_64_209 VGND VGND VPWR VPWR sky130_fd_sc_hd__fill_1
XFILLER_17_169 VGND VGND VPWR VPWR sky130_fd_sc_hd__fill_1
XFILLER_33_607 VGND VGND VPWR VPWR sky130_fd_sc_hd__decap_8
XFILLER_45_478 VGND VGND VPWR VPWR sky130_fd_sc_hd__decap_4
XFILLER_32_139 VGND VGND VPWR VPWR sky130_fd_sc_hd__fill_1
XFILLER_9_302 VGND VGND VPWR VPWR sky130_fd_sc_hd__decap_4
XFILLER_41_673 VGND VGND VPWR VPWR sky130_fd_sc_hd__decap_4
XANTENNA__4556__B1 _3544_/X VGND VGND VPWR VPWR sky130_fd_sc_hd__diode_2
XFILLER_68_504 VGND VGND VPWR VPWR sky130_fd_sc_hd__fill_1
XANTENNA__2885__A3 _2895_/C VGND VGND VPWR VPWR sky130_fd_sc_hd__diode_2
X_3100_ _5682_/Q _3103_/C VGND VGND VPWR VPWR _3101_/B sky130_fd_sc_hd__and2_1
X_4080_ _4080_/A _4081_/B VGND VGND VPWR VPWR _5670_/D sky130_fd_sc_hd__nor2_1
X_3031_ _2993_/X _3030_/X _3138_/B VGND VGND VPWR VPWR _3031_/X sky130_fd_sc_hd__a21o_1
XFILLER_24_607 VPWR VGND VPWR VGND sky130_ef_sc_hd__decap_12
X_4982_ _4183_/X _5038_/A2 _5038_/B1 _4883_/X VGND VGND VPWR VPWR _4982_/X sky130_fd_sc_hd__a22o_1
XFILLER_17_681 VGND VGND VPWR VPWR sky130_fd_sc_hd__fill_1
XTAP_TAPCELL_ROW_34_602 VGND VPWR sky130_fd_sc_hd__tapvpwrvgnd_1
XANTENNA__4795__A0 _5467_/Q VGND VGND VPWR VPWR sky130_fd_sc_hd__diode_2
XTAP_TAPCELL_ROW_62_955 VGND VPWR sky130_fd_sc_hd__tapvpwrvgnd_1
X_3933_ _5591_/Q _3549_/Y _3940_/S VGND VGND VPWR VPWR _5591_/D sky130_fd_sc_hd__mux2_1
X_3864_ _3887_/A _5857_/Q VGND VGND VPWR VPWR _3864_/X sky130_fd_sc_hd__and2_1
XFILLER_31_161 VGND VGND VPWR VPWR sky130_fd_sc_hd__fill_1
XFILLER_32_673 VGND VGND VPWR VPWR sky130_fd_sc_hd__fill_1
X_2815_ _2815_/A _2815_/B _2815_/C _2815_/D VGND VGND VPWR VPWR _2815_/X sky130_fd_sc_hd__or4_1
X_5603_ _5697_/CLK _5603_/D fanout320/X VGND VGND VPWR VPWR _5603_/Q sky130_fd_sc_hd__dfrtp_1
XANTENNA__4547__B1 _4829_/B VGND VGND VPWR VPWR sky130_fd_sc_hd__diode_2
X_3795_ _3376_/X _3767_/A _3794_/X _3906_/A2 VGND VGND VPWR VPWR _4101_/B sky130_fd_sc_hd__a22oi_2
X_2746_ _4487_/B VGND VGND VPWR VPWR _3656_/A sky130_fd_sc_hd__inv_2
X_5534_ _5635_/CLK _5534_/D VGND VGND VPWR VPWR hold70/A sky130_fd_sc_hd__dfxtp_1
X_5465_ _5686_/CLK _5465_/D fanout321/X VGND VGND VPWR VPWR _5465_/Q sky130_fd_sc_hd__dfrtp_2
X_4416_ _4430_/A _4416_/B VGND VGND VPWR VPWR _4418_/B sky130_fd_sc_hd__nand2_1
Xfanout303 fanout309/X VGND VGND VPWR VPWR fanout303/X sky130_fd_sc_hd__clkbuf_2
XANTENNA__2787__B _2871_/C VGND VGND VPWR VPWR sky130_fd_sc_hd__diode_2
X_5396_ _5366_/A _5395_/Y _5391_/Y VGND VGND VPWR VPWR _6167_/D sky130_fd_sc_hd__o21ai_1
Xfanout314 fanout324/X VGND VGND VPWR VPWR fanout314/X sky130_fd_sc_hd__buf_2
Xfanout347 fanout351/X VGND VGND VPWR VPWR fanout347/X sky130_fd_sc_hd__clkbuf_4
XFILLER_59_515 VGND VGND VPWR VPWR sky130_fd_sc_hd__fill_1
Xfanout336 fanout341/X VGND VGND VPWR VPWR fanout336/X sky130_fd_sc_hd__clkbuf_4
X_4347_ _3663_/A _4346_/X _4399_/B _5353_/B VGND VGND VPWR VPWR _4349_/B sky130_fd_sc_hd__a211o_1
Xfanout325 fanout326/X VGND VGND VPWR VPWR fanout325/X sky130_fd_sc_hd__clkbuf_4
X_4278_ _5716_/Q _4308_/A2 _4250_/Y _4277_/X VGND VGND VPWR VPWR _4278_/X sky130_fd_sc_hd__a22o_1
XFILLER_59_559 VGND VGND VPWR VPWR sky130_fd_sc_hd__fill_1
X_6017_ _6021_/CLK _6017_/D fanout344/X VGND VGND VPWR VPWR _6017_/Q sky130_fd_sc_hd__dfrtp_1
X_3229_ _4973_/A0 _5494_/Q _3229_/S VGND VGND VPWR VPWR _5494_/D sky130_fd_sc_hd__mux2_1
XANTENNA_fanout181_X _2917_/A2 VGND VGND VPWR VPWR sky130_fd_sc_hd__diode_2
XTAP_TAPCELL_ROW_68_1032 VGND VPWR sky130_fd_sc_hd__tapvpwrvgnd_1
XFILLER_54_253 VGND VGND VPWR VPWR sky130_fd_sc_hd__fill_1
XFILLER_15_607 VGND VGND VPWR VPWR sky130_fd_sc_hd__fill_2
XANTENNA__4786__A0 _5524_/Q VGND VGND VPWR VPWR sky130_fd_sc_hd__diode_2
XTAP_TAPCELL_ROW_12_329 VGND VPWR sky130_fd_sc_hd__tapvpwrvgnd_1
XTAP_TAPCELL_ROW_79_1172 VGND VPWR sky130_fd_sc_hd__tapvpwrvgnd_1
XANTENNA__4669__S _4687_/S VGND VGND VPWR VPWR sky130_fd_sc_hd__diode_2
XANTENNA__3761__A1 _4813_/A1 VGND VGND VPWR VPWR sky130_fd_sc_hd__diode_2
XANTENNA__3426__X _3434_/S VGND VGND VPWR VPWR sky130_fd_sc_hd__diode_2
Xhold390 _6033_/Q VGND VGND VPWR VPWR hold390/X sky130_fd_sc_hd__dlygate4sd3_1
XANTENNA__4710__B1 _4750_/C1 VGND VGND VPWR VPWR sky130_fd_sc_hd__diode_2
XFILLER_65_507 VGND VGND VPWR VPWR sky130_fd_sc_hd__fill_1
XFILLER_18_401 VGND VGND VPWR VPWR sky130_fd_sc_hd__fill_1
XANTENNA__3602__A _4428_/A VGND VGND VPWR VPWR sky130_fd_sc_hd__diode_2
XANTENNA__5797__Q _5797_/Q VGND VGND VPWR VPWR sky130_fd_sc_hd__diode_2
XFILLER_45_231 VGND VGND VPWR VPWR sky130_fd_sc_hd__fill_1
XFILLER_45_253 VGND VGND VPWR VPWR sky130_fd_sc_hd__fill_1
XFILLER_9_110 VGND VGND VPWR VPWR sky130_fd_sc_hd__fill_2
XANTENNA__3201__A0 _4967_/A0 VGND VGND VPWR VPWR sky130_fd_sc_hd__diode_2
XANTENNA_clkbuf_leaf_20_clk_A clkbuf_leaf_9_clk/A VGND VGND VPWR VPWR sky130_fd_sc_hd__diode_2
X_3580_ _6104_/Q _3656_/A VGND VGND VPWR VPWR _3674_/B sky130_fd_sc_hd__and2_1
X_5250_ _3239_/Y _3492_/B _5230_/B _5341_/B2 _5353_/B VGND VGND VPWR VPWR _5250_/Y
+ sky130_fd_sc_hd__a311oi_2
X_4201_ hold102/X _4200_/X _4246_/S VGND VGND VPWR VPWR _5704_/D sky130_fd_sc_hd__mux2_1
XFILLER_5_393 VGND VGND VPWR VPWR sky130_fd_sc_hd__fill_2
XANTENNA_clkbuf_leaf_35_clk_A clkload1/A VGND VGND VPWR VPWR sky130_fd_sc_hd__diode_2
XANTENNA__4701__A0 _5761_/Q VGND VGND VPWR VPWR sky130_fd_sc_hd__diode_2
XFILLER_47_3 VGND VGND VPWR VPWR sky130_fd_sc_hd__decap_6
X_5181_ _6103_/Q _3623_/A _5185_/S VGND VGND VPWR VPWR _6103_/D sky130_fd_sc_hd__mux2_1
X_4132_ _4164_/B _4148_/B _4148_/C VGND VGND VPWR VPWR _4319_/A sky130_fd_sc_hd__or3_1
XFILLER_3_51 VGND VGND VPWR VPWR sky130_fd_sc_hd__decap_4
X_4063_ _3967_/A _4063_/B VGND VGND VPWR VPWR _4063_/X sky130_fd_sc_hd__and2b_1
X_3014_ _5676_/Q _5596_/Q _2958_/X _5605_/Q VGND VGND VPWR VPWR _3014_/X sky130_fd_sc_hd__a22o_1
XANTENNA__4480__A2 _3623_/A VGND VGND VPWR VPWR sky130_fd_sc_hd__diode_2
XFILLER_36_253 VPWR VGND VPWR VGND sky130_ef_sc_hd__decap_12
XTAP_TAPCELL_ROW_47_771 VGND VPWR sky130_fd_sc_hd__tapvpwrvgnd_1
X_4965_ _4727_/X _4971_/A2 _4971_/B1 _4964_/X VGND VGND VPWR VPWR _4965_/X sky130_fd_sc_hd__a22o_1
XFILLER_24_459 VGND VGND VPWR VPWR sky130_fd_sc_hd__fill_2
X_3916_ _3912_/Y _4114_/B _3916_/S VGND VGND VPWR VPWR _3916_/X sky130_fd_sc_hd__mux2_1
XANTENNA_fanout141_A _5026_/A2 VGND VGND VPWR VPWR sky130_fd_sc_hd__diode_2
X_4896_ _4223_/X _4878_/A _4878_/B _4895_/X VGND VGND VPWR VPWR _4896_/X sky130_fd_sc_hd__a22o_1
XANTENNA__2794__A2 _2916_/B VGND VGND VPWR VPWR sky130_fd_sc_hd__diode_2
X_3847_ _5575_/Q _3859_/C VGND VGND VPWR VPWR _3860_/B sky130_fd_sc_hd__and2_1
XFILLER_20_698 VGND VGND VPWR VPWR sky130_fd_sc_hd__fill_2
X_3778_ _4404_/A _4762_/C _3777_/X _3845_/B VGND VGND VPWR VPWR _3783_/B sky130_fd_sc_hd__a211o_1
XANTENNA__5193__B1 _4539_/X VGND VGND VPWR VPWR sky130_fd_sc_hd__diode_2
X_5517_ _6085_/CLK _5517_/D fanout331/X VGND VGND VPWR VPWR _5517_/Q sky130_fd_sc_hd__dfrtp_4
XANTENNA__4940__A0 _5471_/Q VGND VGND VPWR VPWR sky130_fd_sc_hd__diode_2
X_2729_ _6133_/Q VGND VGND VPWR VPWR _3470_/A sky130_fd_sc_hd__inv_2
X_5448_ _6174_/Q _5453_/B _5443_/X VGND VGND VPWR VPWR _5451_/A sky130_fd_sc_hd__a21o_1
Xfanout122 _5026_/B1 VGND VGND VPWR VPWR _5038_/B1 sky130_fd_sc_hd__clkbuf_4
Xfanout100 _5140_/Y VGND VGND VPWR VPWR _5170_/S sky130_fd_sc_hd__buf_2
Xfanout111 _4855_/S VGND VGND VPWR VPWR _4864_/S sky130_fd_sc_hd__clkbuf_4
X_5379_ _5372_/B _5372_/C _5372_/A VGND VGND VPWR VPWR _5381_/B sky130_fd_sc_hd__o21bai_1
Xfanout144 _4876_/Y VGND VGND VPWR VPWR _4971_/A2 sky130_fd_sc_hd__buf_2
Xfanout155 _3240_/A VGND VGND VPWR VPWR _5192_/A2 sky130_fd_sc_hd__clkbuf_2
Xfanout166 _2970_/X VGND VGND VPWR VPWR _4679_/S sky130_fd_sc_hd__buf_2
Xfanout177 _2789_/X VGND VGND VPWR VPWR _2886_/B sky130_fd_sc_hd__clkbuf_4
Xfanout199 _6124_/Q VGND VGND VPWR VPWR _5217_/A sky130_fd_sc_hd__buf_2
Xfanout188 _6173_/Q VGND VGND VPWR VPWR _5201_/B sky130_fd_sc_hd__buf_2
XANTENNA__4518__A _4522_/C VGND VGND VPWR VPWR sky130_fd_sc_hd__diode_2
XPHY_EDGE_ROW_29_Right_29 VGND VGND VPWR VPWR sky130_fd_sc_hd__decap_3
XANTENNA_fanout54_A _4686_/B1 VGND VGND VPWR VPWR sky130_fd_sc_hd__diode_2
XFILLER_27_253 VPWR VGND VPWR VGND sky130_ef_sc_hd__decap_12
XANTENNA__4952__S _4973_/S VGND VGND VPWR VPWR sky130_fd_sc_hd__diode_2
XFILLER_15_459 VGND VGND VPWR VPWR sky130_fd_sc_hd__fill_2
XTAP_TAPCELL_ROW_25_487 VGND VPWR sky130_fd_sc_hd__tapvpwrvgnd_1
XTAP_TAPCELL_ROW_25_498 VGND VPWR sky130_fd_sc_hd__tapvpwrvgnd_1
XFILLER_7_614 VGND VGND VPWR VPWR sky130_fd_sc_hd__fill_2
XPHY_EDGE_ROW_38_Right_38 VGND VGND VPWR VPWR sky130_fd_sc_hd__decap_3
XFILLER_10_153 VGND VGND VPWR VPWR sky130_fd_sc_hd__decap_6
XANTENNA__4931__A0 _5468_/Q VGND VGND VPWR VPWR sky130_fd_sc_hd__diode_2
XFILLER_12_82 VGND VGND VPWR VPWR sky130_fd_sc_hd__fill_2
XFILLER_78_621 VGND VGND VPWR VPWR sky130_fd_sc_hd__fill_1
XFILLER_33_9 VGND VGND VPWR VPWR sky130_fd_sc_hd__fill_1
XPHY_EDGE_ROW_47_Right_47 VGND VGND VPWR VPWR sky130_fd_sc_hd__decap_3
XANTENNA__4428__A _4428_/A VGND VGND VPWR VPWR sky130_fd_sc_hd__diode_2
XFILLER_18_220 VPWR VGND VPWR VGND sky130_ef_sc_hd__decap_12
XANTENNA__4998__B1 _5024_/B1 VGND VGND VPWR VPWR sky130_fd_sc_hd__diode_2
XFILLER_33_223 VGND VGND VPWR VPWR sky130_fd_sc_hd__fill_1
XFILLER_33_245 VPWR VGND VPWR VGND sky130_ef_sc_hd__decap_12
XTAP_TAPCELL_ROW_44_730 VGND VPWR sky130_fd_sc_hd__tapvpwrvgnd_1
XANTENNA__5411__A1 _5406_/A VGND VGND VPWR VPWR sky130_fd_sc_hd__diode_2
X_4750_ _4750_/A1 _4749_/X _4748_/X _4750_/C1 VGND VGND VPWR VPWR _4750_/X sky130_fd_sc_hd__o211a_1
XPHY_EDGE_ROW_56_Right_56 VGND VGND VPWR VPWR sky130_fd_sc_hd__decap_3
X_4681_ hold333/X _4745_/A2 _4680_/X VGND VGND VPWR VPWR _5783_/D sky130_fd_sc_hd__o21a_1
X_3701_ _3701_/A _3721_/A _3721_/B _3701_/D VGND VGND VPWR VPWR _3701_/X sky130_fd_sc_hd__or4_1
X_3632_ _3632_/A _3632_/B _3632_/C VGND VGND VPWR VPWR _3632_/X sky130_fd_sc_hd__and3_1
XANTENNA__5175__B1 _4166_/C VGND VGND VPWR VPWR sky130_fd_sc_hd__diode_2
XANTENNA__4922__A0 _5493_/Q VGND VGND VPWR VPWR sky130_fd_sc_hd__diode_2
X_5302_ _5301_/A _5301_/B _5301_/C VGND VGND VPWR VPWR _5303_/B sky130_fd_sc_hd__a21oi_1
X_3563_ _3564_/B _3563_/B _3563_/C _3563_/D VGND VGND VPWR VPWR _5195_/B sky130_fd_sc_hd__and4b_1
X_3494_ _3495_/A _3495_/B VGND VGND VPWR VPWR _3545_/A sky130_fd_sc_hd__nor2_1
XPHY_EDGE_ROW_65_Right_65 VGND VGND VPWR VPWR sky130_fd_sc_hd__decap_3
X_5233_ _5204_/B _5230_/X _5231_/B VGND VGND VPWR VPWR _5233_/X sky130_fd_sc_hd__o21a_1
X_5164_ hold234/X _5474_/Q _5172_/S VGND VGND VPWR VPWR _6086_/D sky130_fd_sc_hd__mux2_1
X_4115_ _4115_/A _4115_/B _4115_/C _4112_/Y VGND VGND VPWR VPWR _4130_/A sky130_fd_sc_hd__or4b_1
X_5095_ hold129/X _5728_/Q _5099_/S VGND VGND VPWR VPWR _6018_/D sky130_fd_sc_hd__mux2_1
XANTENNA__2784__C _2871_/C VGND VGND VPWR VPWR sky130_fd_sc_hd__diode_2
XFILLER_29_529 VPWR VGND VPWR VGND sky130_ef_sc_hd__decap_12
X_4046_ hold59/A hold63/A _4052_/S VGND VGND VPWR VPWR _4046_/X sky130_fd_sc_hd__mux2_1
XFILLER_52_521 VGND VGND VPWR VPWR sky130_fd_sc_hd__fill_1
XPHY_EDGE_ROW_74_Right_74 VGND VGND VPWR VPWR sky130_fd_sc_hd__decap_3
X_5997_ _6085_/CLK _5997_/D fanout342/X VGND VGND VPWR VPWR _5997_/Q sky130_fd_sc_hd__dfrtp_1
XFILLER_24_278 VGND VGND VPWR VPWR sky130_fd_sc_hd__fill_1
X_4948_ hold441/X _4948_/A2 _4947_/X VGND VGND VPWR VPWR _5925_/D sky130_fd_sc_hd__a21o_1
X_4879_ _4943_/S _4879_/B VGND VGND VPWR VPWR _4901_/S sky130_fd_sc_hd__nand2_4
XTAP_TAPCELL_ROW_22_457 VGND VPWR sky130_fd_sc_hd__tapvpwrvgnd_1
XTAP_TAPCELL_ROW_50_799 VGND VPWR sky130_fd_sc_hd__tapvpwrvgnd_1
XANTENNA__4913__A0 _5490_/Q VGND VGND VPWR VPWR sky130_fd_sc_hd__diode_2
XTAP_TAPCELL_ROW_76_1131 VGND VPWR sky130_fd_sc_hd__tapvpwrvgnd_1
XANTENNA__5108__S _5127_/B VGND VGND VPWR VPWR sky130_fd_sc_hd__diode_2
XANTENNA__4692__A2 _4748_/A2 VGND VGND VPWR VPWR sky130_fd_sc_hd__diode_2
XFILLER_58_78 VGND VGND VPWR VPWR sky130_fd_sc_hd__decap_6
XFILLER_59_197 VGND VGND VPWR VPWR sky130_fd_sc_hd__fill_1
XANTENNA_fanout57_X _5066_/S VGND VGND VPWR VPWR sky130_fd_sc_hd__diode_2
XTAP_TAPCELL_ROW_58_899 VGND VPWR sky130_fd_sc_hd__tapvpwrvgnd_1
XANTENNA__3404__A0 _4964_/A0 VGND VGND VPWR VPWR sky130_fd_sc_hd__diode_2
XPHY_EDGE_ROW_4_Left_85 VGND VGND VPWR VPWR sky130_fd_sc_hd__decap_3
XFILLER_30_248 VGND VGND VPWR VPWR sky130_fd_sc_hd__decap_4
XANTENNA__4904__A0 _5487_/Q VGND VGND VPWR VPWR sky130_fd_sc_hd__diode_2
XANTENNA__4857__S _4864_/S VGND VGND VPWR VPWR sky130_fd_sc_hd__diode_2
XFILLER_38_304 VGND VGND VPWR VPWR sky130_fd_sc_hd__decap_4
XANTENNA_clkbuf_2_2__f_clk_A clkbuf_0_clk/X VGND VGND VPWR VPWR sky130_fd_sc_hd__diode_2
X_5920_ _6097_/CLK _5920_/D fanout302/X VGND VGND VPWR VPWR _5920_/Q sky130_fd_sc_hd__dfrtp_1
XFILLER_0_41 VPWR VGND VPWR VGND sky130_ef_sc_hd__decap_12
XFILLER_80_148 VGND VGND VPWR VPWR sky130_fd_sc_hd__decap_3
XFILLER_0_85 VPWR VGND VPWR VGND sky130_ef_sc_hd__decap_12
X_5851_ _6026_/CLK _5851_/D fanout279/X VGND VGND VPWR VPWR _5851_/Q sky130_fd_sc_hd__dfrtp_1
X_4802_ _5474_/Q hold272/X _4810_/S VGND VGND VPWR VPWR _5839_/D sky130_fd_sc_hd__mux2_1
X_5782_ _6032_/CLK _5782_/D fanout291/X VGND VGND VPWR VPWR _5782_/Q sky130_fd_sc_hd__dfrtp_1
X_2994_ _3150_/C _3150_/B VGND VGND VPWR VPWR _4618_/S sky130_fd_sc_hd__and2b_1
X_4733_ _5765_/Q _5965_/Q _4735_/S VGND VGND VPWR VPWR _4733_/X sky130_fd_sc_hd__mux2_1
XFILLER_21_248 VGND VGND VPWR VPWR sky130_fd_sc_hd__decap_4
XANTENNA__3946__A1 _3544_/X VGND VGND VPWR VPWR sky130_fd_sc_hd__diode_2
X_4664_ _4660_/X _4662_/X _4663_/X _4688_/B2 _4720_/C1 VGND VGND VPWR VPWR _4664_/X
+ sky130_fd_sc_hd__a221o_1
X_4595_ _5915_/Q _4684_/A2 _4667_/B1 _4594_/X VGND VGND VPWR VPWR _4595_/X sky130_fd_sc_hd__a22o_1
X_3615_ _4452_/A _6055_/Q VGND VGND VPWR VPWR _3615_/X sky130_fd_sc_hd__and2_1
X_3546_ _3511_/Y _3546_/B VGND VGND VPWR VPWR _3547_/B sky130_fd_sc_hd__nand2b_1
X_5216_ _5217_/A _5217_/B VGND VGND VPWR VPWR _5218_/B sky130_fd_sc_hd__or2_1
X_3477_ _3479_/B VGND VGND VPWR VPWR _3477_/Y sky130_fd_sc_hd__inv_2
X_6196_ _6196_/A VGND VGND VPWR VPWR uio_oe[5] sky130_fd_sc_hd__buf_2
XTAP_TAPCELL_ROW_71_1072 VGND VPWR sky130_fd_sc_hd__tapvpwrvgnd_1
X_5147_ hold160/X _5523_/Q _5167_/S VGND VGND VPWR VPWR _6069_/D sky130_fd_sc_hd__mux2_1
XFILLER_28_15 VGND VGND VPWR VPWR sky130_fd_sc_hd__decap_3
X_5078_ hold295/X _5489_/Q _5098_/S VGND VGND VPWR VPWR _6001_/D sky130_fd_sc_hd__mux2_1
XFILLER_56_145 VGND VGND VPWR VPWR sky130_fd_sc_hd__decap_8
X_4029_ hold405/X _4027_/B _4028_/Y VGND VGND VPWR VPWR _5655_/D sky130_fd_sc_hd__o21a_1
XTAP_TAPCELL_ROW_27_516 VGND VPWR sky130_fd_sc_hd__tapvpwrvgnd_1
XTAP_TAPCELL_ROW_55_869 VGND VPWR sky130_fd_sc_hd__tapvpwrvgnd_1
XANTENNA__3937__A1 _3544_/X VGND VGND VPWR VPWR sky130_fd_sc_hd__diode_2
XFILLER_8_219 VPWR VGND VPWR VGND sky130_ef_sc_hd__decap_12
XANTENNA__5139__B1 _4175_/D VGND VGND VPWR VPWR sky130_fd_sc_hd__diode_2
X_5463__4 _5966_/CLK VGND VGND VPWR VPWR _5732_/CLK sky130_fd_sc_hd__inv_2
XFILLER_69_11 VGND VGND VPWR VPWR sky130_fd_sc_hd__fill_1
XANTENNA__3306__A_N _5201_/B VGND VGND VPWR VPWR sky130_fd_sc_hd__diode_2
XANTENNA__2912__A2 _2917_/A2 VGND VGND VPWR VPWR sky130_fd_sc_hd__diode_2
XFILLER_69_55 VGND VGND VPWR VPWR sky130_fd_sc_hd__fill_1
XTAP_TAPCELL_ROW_7_263 VGND VPWR sky130_fd_sc_hd__tapvpwrvgnd_1
XFILLER_0_697 VGND VGND VPWR VPWR sky130_fd_sc_hd__decap_3
XFILLER_31_513 VGND VGND VPWR VPWR sky130_fd_sc_hd__fill_1
XFILLER_34_91 VGND VGND VPWR VPWR sky130_fd_sc_hd__fill_1
Xhold208 _6121_/Q VGND VGND VPWR VPWR hold208/X sky130_fd_sc_hd__dlygate4sd3_1
Xhold219 _6010_/Q VGND VGND VPWR VPWR hold219/X sky130_fd_sc_hd__dlygate4sd3_1
X_3400_ _2824_/C _5517_/Q _3407_/S VGND VGND VPWR VPWR _5517_/D sky130_fd_sc_hd__mux2_1
X_4380_ _4829_/C _4380_/B VGND VGND VPWR VPWR _4380_/Y sky130_fd_sc_hd__nand2_1
X_3331_ _3905_/A _6034_/Q VGND VGND VPWR VPWR _3332_/D sky130_fd_sc_hd__xor2_1
X_3262_ _6129_/D _3265_/B VGND VGND VPWR VPWR _3480_/B sky130_fd_sc_hd__nand2_1
X_6050_ _6050_/CLK _6050_/D fanout299/X VGND VGND VPWR VPWR hold91/A sky130_fd_sc_hd__dfrtp_1
X_5001_ hold474/X _5027_/A2 _5000_/X VGND VGND VPWR VPWR _5946_/D sky130_fd_sc_hd__a21o_1
X_3193_ _5901_/Q _5719_/Q _4109_/C VGND VGND VPWR VPWR _3399_/C sky130_fd_sc_hd__and3_2
X_5903_ _5967_/CLK _5903_/D fanout306/X VGND VGND VPWR VPWR _5903_/Q sky130_fd_sc_hd__dfrtp_1
X_5834_ _6093_/CLK _5834_/D fanout345/X VGND VGND VPWR VPWR _5834_/Q sky130_fd_sc_hd__dfrtp_1
XTAP_TAPCELL_ROW_52_828 VGND VPWR sky130_fd_sc_hd__tapvpwrvgnd_1
XFILLER_34_373 VGND VGND VPWR VPWR sky130_fd_sc_hd__fill_2
XANTENNA__3919__B2 _3918_/X VGND VGND VPWR VPWR sky130_fd_sc_hd__diode_2
X_2977_ _2977_/A _2980_/A _3129_/B VGND VGND VPWR VPWR _2977_/Y sky130_fd_sc_hd__nor3b_4
XTAP_TAPCELL_ROW_32_574 VGND VPWR sky130_fd_sc_hd__tapvpwrvgnd_1
XANTENNA__5447__A _5447_/A VGND VGND VPWR VPWR sky130_fd_sc_hd__diode_2
X_5765_ _6163_/CLK _5765_/D fanout325/X VGND VGND VPWR VPWR _5765_/Q sky130_fd_sc_hd__dfrtp_4
X_4716_ _5963_/Q _4748_/A2 _4243_/S _4715_/X VGND VGND VPWR VPWR _4716_/X sky130_fd_sc_hd__a211o_1
XANTENNA__4592__B2 _4672_/A1 VGND VGND VPWR VPWR sky130_fd_sc_hd__diode_2
XANTENNA__4351__A _5736_/Q VGND VGND VPWR VPWR sky130_fd_sc_hd__diode_2
XANTENNA__3395__A2 _3396_/A VGND VGND VPWR VPWR sky130_fd_sc_hd__diode_2
XTAP_TAPCELL_ROW_32_585 VGND VPWR sky130_fd_sc_hd__tapvpwrvgnd_1
X_5696_ _5696_/CLK _5696_/D VGND VGND VPWR VPWR hold56/A sky130_fd_sc_hd__dfxtp_1
X_4647_ _5921_/Q _5762_/Q _4687_/S VGND VGND VPWR VPWR _4647_/X sky130_fd_sc_hd__mux2_1
XANTENNA_fanout107_X _4951_/A2 VGND VGND VPWR VPWR sky130_fd_sc_hd__diode_2
X_4578_ _5489_/Q _5795_/Q _4610_/S VGND VGND VPWR VPWR _4578_/X sky130_fd_sc_hd__mux2_1
XFILLER_1_417 VPWR VGND VPWR VGND sky130_ef_sc_hd__decap_12
X_3529_ _3501_/X _3528_/B _3528_/C _3500_/X VGND VGND VPWR VPWR _3529_/X sky130_fd_sc_hd__a31o_1
XTAP_TAPCELL_ROW_4_233 VGND VPWR sky130_fd_sc_hd__tapvpwrvgnd_1
XANTENNA__6033__RESET_B fanout287/X VGND VGND VPWR VPWR sky130_fd_sc_hd__diode_2
XFILLER_69_281 VGND VGND VPWR VPWR sky130_fd_sc_hd__decap_3
XFILLER_29_167 VGND VGND VPWR VPWR sky130_fd_sc_hd__fill_1
XFILLER_55_68 VGND VGND VPWR VPWR sky130_fd_sc_hd__fill_1
XFILLER_72_479 VGND VGND VPWR VPWR sky130_fd_sc_hd__fill_1
XFILLER_13_502 VGND VGND VPWR VPWR sky130_fd_sc_hd__fill_2
XFILLER_71_23 VGND VGND VPWR VPWR sky130_fd_sc_hd__fill_2
XFILLER_13_546 VGND VGND VPWR VPWR sky130_fd_sc_hd__fill_1
XFILLER_71_78 VGND VGND VPWR VPWR sky130_fd_sc_hd__fill_1
XFILLER_71_67 VGND VGND VPWR VPWR sky130_fd_sc_hd__decap_6
XFILLER_40_365 VPWR VGND VPWR VGND sky130_ef_sc_hd__decap_12
XANTENNA__4583__A1 _5762_/Q VGND VGND VPWR VPWR sky130_fd_sc_hd__diode_2
XANTENNA__3791__C1 _3905_/B VGND VGND VPWR VPWR sky130_fd_sc_hd__diode_2
XANTENNA__3605__A _4464_/A VGND VGND VPWR VPWR sky130_fd_sc_hd__diode_2
XFILLER_4_299 VGND VGND VPWR VPWR sky130_fd_sc_hd__decap_8
XFILLER_0_461 VPWR VGND VPWR VGND sky130_ef_sc_hd__decap_12
XFILLER_75_273 VGND VGND VPWR VPWR sky130_fd_sc_hd__fill_1
Xhold80 hold80/A VGND VGND VPWR VPWR hold80/X sky130_fd_sc_hd__dlygate4sd3_1
Xhold91 hold91/A VGND VGND VPWR VPWR hold91/X sky130_fd_sc_hd__dlygate4sd3_1
XANTENNA__3340__A _6174_/Q VGND VGND VPWR VPWR sky130_fd_sc_hd__diode_2
X_2900_ _2783_/X _2884_/X _2889_/X _2803_/Y _2722_/Y VGND VGND VPWR VPWR _2901_/D
+ sky130_fd_sc_hd__a221o_1
XFILLER_44_671 VGND VGND VPWR VPWR sky130_fd_sc_hd__fill_2
X_3880_ _6174_/Q _3880_/B _3893_/C VGND VGND VPWR VPWR _3880_/X sky130_fd_sc_hd__and3_1
X_2831_ _2831_/A _2831_/B _2842_/B VGND VGND VPWR VPWR _2831_/Y sky130_fd_sc_hd__nor3_1
XFILLER_31_376 VGND VGND VPWR VPWR sky130_fd_sc_hd__fill_2
XFILLER_77_3 VGND VGND VPWR VPWR sky130_fd_sc_hd__decap_4
X_2762_ _5701_/Q VGND VGND VPWR VPWR _4247_/A sky130_fd_sc_hd__inv_2
X_5550_ _6120_/CLK _5550_/D VGND VGND VPWR VPWR hold60/A sky130_fd_sc_hd__dfxtp_1
XANTENNA__3377__A2 _3396_/A VGND VGND VPWR VPWR sky130_fd_sc_hd__diode_2
XANTENNA__4574__A1 _4686_/A1 VGND VGND VPWR VPWR sky130_fd_sc_hd__diode_2
X_5481_ _5645_/CLK _5481_/D VGND VGND VPWR VPWR hold48/A sky130_fd_sc_hd__dfxtp_1
X_4501_ _3639_/A _4357_/B _4500_/X VGND VGND VPWR VPWR _5747_/D sky130_fd_sc_hd__a21o_1
X_4432_ _4447_/A _4444_/C VGND VGND VPWR VPWR _4432_/Y sky130_fd_sc_hd__nand2_1
X_4363_ _5737_/Q _4439_/B VGND VGND VPWR VPWR _4364_/C sky130_fd_sc_hd__nor2_1
X_4294_ _5714_/Q _4293_/X _4312_/S VGND VGND VPWR VPWR _5714_/D sky130_fd_sc_hd__mux2_1
X_6102_ _6107_/CLK _6102_/D fanout272/X VGND VGND VPWR VPWR _6102_/Q sky130_fd_sc_hd__dfrtp_1
X_3314_ _5442_/A _5988_/Q VGND VGND VPWR VPWR _3343_/B sky130_fd_sc_hd__and2_1
X_3245_ _3565_/A _3245_/B VGND VGND VPWR VPWR _3517_/B sky130_fd_sc_hd__nor2_2
X_6033_ clkload5/A _6033_/D fanout287/X VGND VGND VPWR VPWR _6033_/Q sky130_fd_sc_hd__dfrtp_1
X_3176_ _5720_/Q _3183_/B VGND VGND VPWR VPWR _3179_/B sky130_fd_sc_hd__nand2_2
XANTENNA_fanout171_A _2964_/B VGND VGND VPWR VPWR sky130_fd_sc_hd__diode_2
XFILLER_27_638 VGND VGND VPWR VPWR sky130_fd_sc_hd__decap_6
XANTENNA_fanout269_A _5477_/Q VGND VGND VPWR VPWR sky130_fd_sc_hd__diode_2
XTAP_TAPCELL_ROW_37_644 VGND VPWR sky130_fd_sc_hd__tapvpwrvgnd_1
XTAP_TAPCELL_ROW_65_997 VGND VPWR sky130_fd_sc_hd__tapvpwrvgnd_1
XANTENNA__4780__S _4805_/S VGND VGND VPWR VPWR sky130_fd_sc_hd__diode_2
XTAP_TAPCELL_ROW_17_390 VGND VPWR sky130_fd_sc_hd__tapvpwrvgnd_1
XFILLER_22_332 VPWR VGND VPWR VGND sky130_ef_sc_hd__decap_12
X_5817_ _6092_/CLK _5817_/D fanout336/X VGND VGND VPWR VPWR _5817_/Q sky130_fd_sc_hd__dfrtp_1
XANTENNA__4565__A1 _5760_/Q VGND VGND VPWR VPWR sky130_fd_sc_hd__diode_2
XFILLER_10_549 VGND VGND VPWR VPWR sky130_fd_sc_hd__decap_4
XFILLER_22_387 VPWR VGND VPWR VGND sky130_ef_sc_hd__decap_12
X_5748_ _6026_/CLK _5748_/D fanout280/X VGND VGND VPWR VPWR _5748_/Q sky130_fd_sc_hd__dfrtp_1
X_5679_ _5686_/CLK _5679_/D fanout321/X VGND VGND VPWR VPWR _5679_/Q sky130_fd_sc_hd__dfrtp_1
XANTENNA__4955__S _4973_/S VGND VGND VPWR VPWR sky130_fd_sc_hd__diode_2
XFILLER_57_240 VGND VGND VPWR VPWR sky130_fd_sc_hd__fill_1
XFILLER_45_468 VGND VGND VPWR VPWR sky130_fd_sc_hd__decap_3
XANTENNA__4690__S _4746_/S VGND VGND VPWR VPWR sky130_fd_sc_hd__diode_2
XFILLER_32_118 VGND VGND VPWR VPWR sky130_fd_sc_hd__fill_2
XFILLER_32_129 VGND VGND VPWR VPWR sky130_fd_sc_hd__fill_2
Xclkbuf_leaf_52_clk clkload0/A VGND VGND VPWR VPWR _6061_/CLK sky130_fd_sc_hd__clkbuf_8
XFILLER_13_354 VPWR VGND VPWR VGND sky130_ef_sc_hd__decap_12
XFILLER_40_195 VGND VGND VPWR VPWR sky130_fd_sc_hd__fill_1
XANTENNA__4556__A1 _5764_/Q VGND VGND VPWR VPWR sky130_fd_sc_hd__diode_2
X_3030_ _5523_/Q _3150_/B _6096_/Q _3028_/X _3029_/Y VGND VGND VPWR VPWR _3030_/X
+ sky130_fd_sc_hd__o32a_1
XANTENNA__5590__RESET_B fanout310/X VGND VGND VPWR VPWR sky130_fd_sc_hd__diode_2
XFILLER_24_619 VGND VGND VPWR VPWR sky130_fd_sc_hd__decap_4
X_4981_ hold380/X _5041_/A2 _4980_/X VGND VGND VPWR VPWR _5936_/D sky130_fd_sc_hd__a21o_1
XTAP_TAPCELL_ROW_34_603 VGND VPWR sky130_fd_sc_hd__tapvpwrvgnd_1
XTAP_TAPCELL_ROW_62_956 VGND VPWR sky130_fd_sc_hd__tapvpwrvgnd_1
Xclkbuf_leaf_43_clk clkload1/A VGND VGND VPWR VPWR _5645_/CLK sky130_fd_sc_hd__clkbuf_8
X_3932_ _6125_/Q _3932_/B VGND VGND VPWR VPWR _3940_/S sky130_fd_sc_hd__and2_4
X_3863_ _5576_/Q _3736_/X _3862_/X VGND VGND VPWR VPWR _5576_/D sky130_fd_sc_hd__o21ba_1
XANTENNA_clkbuf_leaf_9_clk_A clkbuf_leaf_9_clk/A VGND VGND VPWR VPWR sky130_fd_sc_hd__diode_2
X_2814_ _2811_/X _2812_/X _2813_/X _2809_/Y VGND VGND VPWR VPWR _2815_/D sky130_fd_sc_hd__o31a_1
XTAP_TAPCELL_ROW_14_360 VGND VPWR sky130_fd_sc_hd__tapvpwrvgnd_1
X_5602_ _5682_/CLK _5602_/D fanout320/X VGND VGND VPWR VPWR _5602_/Q sky130_fd_sc_hd__dfrtp_1
XANTENNA__4547__B2 _5736_/Q VGND VGND VPWR VPWR sky130_fd_sc_hd__diode_2
X_5533_ _5635_/CLK hold24/X VGND VGND VPWR VPWR hold23/A sky130_fd_sc_hd__dfxtp_1
X_3794_ _5805_/Q _3904_/S _3793_/X _3906_/A1 VGND VGND VPWR VPWR _3794_/X sky130_fd_sc_hd__o211a_1
X_2745_ _4487_/A VGND VGND VPWR VPWR _4464_/A sky130_fd_sc_hd__inv_2
XANTENNA__3944__S _5353_/A VGND VGND VPWR VPWR sky130_fd_sc_hd__diode_2
X_4415_ _4424_/A _4439_/B VGND VGND VPWR VPWR _4416_/B sky130_fd_sc_hd__nand2_1
X_5395_ _5395_/A _5395_/B VGND VGND VPWR VPWR _5395_/Y sky130_fd_sc_hd__xnor2_1
Xfanout304 fanout305/X VGND VGND VPWR VPWR fanout304/X sky130_fd_sc_hd__clkbuf_4
X_4346_ _5207_/B _5226_/C VGND VGND VPWR VPWR _4346_/X sky130_fd_sc_hd__and2_1
XANTENNA__2787__C _2864_/A VGND VGND VPWR VPWR sky130_fd_sc_hd__diode_2
Xfanout348 fanout351/X VGND VGND VPWR VPWR fanout348/X sky130_fd_sc_hd__buf_2
Xfanout326 fanout352/X VGND VGND VPWR VPWR fanout326/X sky130_fd_sc_hd__clkbuf_4
Xfanout337 fanout341/X VGND VGND VPWR VPWR fanout337/X sky130_fd_sc_hd__clkbuf_4
Xfanout315 fanout318/X VGND VGND VPWR VPWR fanout315/X sky130_fd_sc_hd__clkbuf_4
X_4277_ _5568_/Q _5576_/Q _4277_/S VGND VGND VPWR VPWR _4277_/X sky130_fd_sc_hd__mux2_1
X_3228_ _4970_/A0 _5493_/Q _3229_/S VGND VGND VPWR VPWR _5493_/D sky130_fd_sc_hd__mux2_1
X_6016_ _6088_/CLK _6016_/D fanout338/X VGND VGND VPWR VPWR _6016_/Q sky130_fd_sc_hd__dfrtp_1
XANTENNA__3286__A1 _5412_/A VGND VGND VPWR VPWR sky130_fd_sc_hd__diode_2
X_3159_ _5907_/Q _2987_/Y _3157_/X _3158_/X _2989_/Y VGND VGND VPWR VPWR _3159_/X
+ sky130_fd_sc_hd__o221a_1
XANTENNA_fanout174_X _2926_/B1 VGND VGND VPWR VPWR sky130_fd_sc_hd__diode_2
XFILLER_27_435 VGND VGND VPWR VPWR sky130_fd_sc_hd__decap_3
XFILLER_36_15 VGND VGND VPWR VPWR sky130_fd_sc_hd__decap_8
XTAP_TAPCELL_ROW_68_1033 VGND VPWR sky130_fd_sc_hd__tapvpwrvgnd_1
XANTENNA__5027__A2 _5027_/A2 VGND VGND VPWR VPWR sky130_fd_sc_hd__diode_2
XFILLER_54_232 VGND VGND VPWR VPWR sky130_fd_sc_hd__fill_1
XFILLER_54_287 VGND VGND VPWR VPWR sky130_fd_sc_hd__fill_1
XANTENNA_fanout341_X fanout341/X VGND VGND VPWR VPWR sky130_fd_sc_hd__diode_2
Xclkbuf_leaf_34_clk clkload2/A VGND VGND VPWR VPWR _6111_/CLK sky130_fd_sc_hd__clkbuf_8
XTAP_TAPCELL_ROW_79_1173 VGND VPWR sky130_fd_sc_hd__tapvpwrvgnd_1
XTAP_TAPCELL_ROW_79_1162 VGND VPWR sky130_fd_sc_hd__tapvpwrvgnd_1
XANTENNA__2978__B _4687_/S VGND VGND VPWR VPWR sky130_fd_sc_hd__diode_2
XANTENNA__3761__A2 _3725_/C VGND VGND VPWR VPWR sky130_fd_sc_hd__diode_2
Xhold380 _5936_/Q VGND VGND VPWR VPWR hold380/X sky130_fd_sc_hd__dlygate4sd3_1
XANTENNA__4710__A1 _4750_/A1 VGND VGND VPWR VPWR sky130_fd_sc_hd__diode_2
XFILLER_7_3 VGND VGND VPWR VPWR sky130_fd_sc_hd__decap_4
Xhold391 _5937_/Q VGND VGND VPWR VPWR hold391/X sky130_fd_sc_hd__dlygate4sd3_1
XANTENNA__4685__S _4687_/S VGND VGND VPWR VPWR sky130_fd_sc_hd__diode_2
XANTENNA__5018__A2 _5026_/A2 VGND VGND VPWR VPWR sky130_fd_sc_hd__diode_2
XFILLER_60_213 VGND VGND VPWR VPWR sky130_fd_sc_hd__fill_1
XFILLER_33_405 VPWR VGND VPWR VGND sky130_ef_sc_hd__decap_12
Xclkbuf_leaf_25_clk clkload2/A VGND VGND VPWR VPWR _6085_/CLK sky130_fd_sc_hd__clkbuf_8
XFILLER_14_641 VGND VGND VPWR VPWR sky130_fd_sc_hd__decap_3
XFILLER_9_133 VGND VGND VPWR VPWR sky130_fd_sc_hd__fill_1
XANTENNA__3201__A1 _5472_/Q VGND VGND VPWR VPWR sky130_fd_sc_hd__diode_2
XFILLER_42_91 VGND VGND VPWR VPWR sky130_fd_sc_hd__fill_1
XANTENNA__3991__C _4005_/S VGND VGND VPWR VPWR sky130_fd_sc_hd__diode_2
X_4200_ _4200_/A _4200_/B VGND VGND VPWR VPWR _4200_/X sky130_fd_sc_hd__or2_1
X_5180_ hold343/X _2744_/A _5185_/S VGND VGND VPWR VPWR _6102_/D sky130_fd_sc_hd__mux2_1
XPHY_EDGE_ROW_79_Left_160 VGND VGND VPWR VPWR sky130_fd_sc_hd__decap_3
X_4131_ _4148_/B _4148_/C VGND VGND VPWR VPWR _4139_/B sky130_fd_sc_hd__nor2_1
XFILLER_68_379 VGND VGND VPWR VPWR sky130_fd_sc_hd__fill_1
XANTENNA__4167__Y _4167_/Y VGND VGND VPWR VPWR sky130_fd_sc_hd__diode_2
XFILLER_3_85 VGND VGND VPWR VPWR sky130_fd_sc_hd__decap_3
X_4062_ hold25/A hold30/A _4070_/S VGND VGND VPWR VPWR _4063_/B sky130_fd_sc_hd__mux2_1
X_3013_ hold148/X _3012_/X _3114_/S VGND VGND VPWR VPWR _6120_/D sky130_fd_sc_hd__mux2_1
XANTENNA__5009__A2 _5025_/A2 VGND VGND VPWR VPWR sky130_fd_sc_hd__diode_2
XTAP_TAPCELL_ROW_47_772 VGND VPWR sky130_fd_sc_hd__tapvpwrvgnd_1
XFILLER_36_265 VPWR VGND VPWR VGND sky130_ef_sc_hd__decap_12
Xclkbuf_leaf_16_clk clkbuf_leaf_9_clk/A VGND VGND VPWR VPWR _5966_/CLK sky130_fd_sc_hd__clkbuf_8
X_4964_ _4964_/A0 _4722_/X _4973_/S VGND VGND VPWR VPWR _4964_/X sky130_fd_sc_hd__mux2_1
XFILLER_17_490 VPWR VGND VPWR VGND sky130_ef_sc_hd__decap_12
X_3915_ _3725_/B _3914_/X _3765_/Y VGND VGND VPWR VPWR _4114_/B sky130_fd_sc_hd__o21a_1
X_4895_ _5798_/Q _5522_/Q _4901_/S VGND VGND VPWR VPWR _4895_/X sky130_fd_sc_hd__mux2_1
XFILLER_20_655 VPWR VGND VPWR VGND sky130_ef_sc_hd__decap_12
X_3846_ _3906_/A2 _3843_/X _3845_/X VGND VGND VPWR VPWR _4116_/C sky130_fd_sc_hd__a21oi_1
X_3777_ _3887_/A _5850_/Q VGND VGND VPWR VPWR _3777_/X sky130_fd_sc_hd__and2_1
XANTENNA__5193__B2 _4829_/C VGND VGND VPWR VPWR sky130_fd_sc_hd__diode_2
XANTENNA__5193__A1 _6114_/Q VGND VGND VPWR VPWR sky130_fd_sc_hd__diode_2
X_2728_ _5217_/A VGND VGND VPWR VPWR _3705_/A sky130_fd_sc_hd__inv_2
X_5516_ _6050_/CLK _5516_/D fanout290/X VGND VGND VPWR VPWR hold89/A sky130_fd_sc_hd__dfrtp_1
XANTENNA_fanout301_A fanout303/X VGND VGND VPWR VPWR sky130_fd_sc_hd__diode_2
X_5447_ _5447_/A _5447_/B VGND VGND VPWR VPWR _5447_/Y sky130_fd_sc_hd__nand2_1
Xfanout101 _5025_/A2 VGND VGND VPWR VPWR _5043_/A2 sky130_fd_sc_hd__clkbuf_4
Xfanout112 _4832_/X VGND VGND VPWR VPWR _4855_/S sky130_fd_sc_hd__buf_2
X_5378_ _5378_/A _5378_/B VGND VGND VPWR VPWR _5381_/A sky130_fd_sc_hd__nor2_1
X_4329_ _4329_/A _4329_/B VGND VGND VPWR VPWR _4338_/C sky130_fd_sc_hd__or2_1
Xfanout145 _4876_/Y VGND VGND VPWR VPWR _4950_/A2 sky130_fd_sc_hd__clkbuf_4
Xfanout123 _5026_/B1 VGND VGND VPWR VPWR _5024_/B1 sky130_fd_sc_hd__clkbuf_4
Xfanout156 _3970_/X VGND VGND VPWR VPWR _4541_/S sky130_fd_sc_hd__buf_2
Xfanout178 _2788_/Y VGND VGND VPWR VPWR _2916_/B sky130_fd_sc_hd__clkbuf_4
Xfanout167 _2967_/X VGND VGND VPWR VPWR _4623_/S sky130_fd_sc_hd__clkbuf_4
Xfanout189 _6172_/Q VGND VGND VPWR VPWR _5427_/A sky130_fd_sc_hd__buf_2
XANTENNA_fanout47_A _4704_/C1 VGND VGND VPWR VPWR sky130_fd_sc_hd__diode_2
XFILLER_27_265 VPWR VGND VPWR VGND sky130_ef_sc_hd__decap_12
XFILLER_70_555 VGND VGND VPWR VPWR sky130_fd_sc_hd__fill_1
XFILLER_63_35 VGND VGND VPWR VPWR sky130_fd_sc_hd__fill_1
XANTENNA__4759__B2 _3541_/Y VGND VGND VPWR VPWR sky130_fd_sc_hd__diode_2
XTAP_TAPCELL_ROW_25_488 VGND VPWR sky130_fd_sc_hd__tapvpwrvgnd_1
XFILLER_10_121 VGND VGND VPWR VPWR sky130_fd_sc_hd__fill_1
XANTENNA__5184__A1 _3647_/A VGND VGND VPWR VPWR sky130_fd_sc_hd__diode_2
XANTENNA__4695__A0 _5760_/Q VGND VGND VPWR VPWR sky130_fd_sc_hd__diode_2
XANTENNA__2995__Y _4746_/S VGND VGND VPWR VPWR sky130_fd_sc_hd__diode_2
XANTENNA__3613__A _4452_/A VGND VGND VPWR VPWR sky130_fd_sc_hd__diode_2
XFILLER_19_711 VGND VGND VPWR VPWR sky130_fd_sc_hd__fill_2
XFILLER_65_349 VGND VGND VPWR VPWR sky130_fd_sc_hd__decap_4
XFILLER_18_232 VGND VGND VPWR VPWR sky130_fd_sc_hd__fill_2
XFILLER_73_371 VGND VGND VPWR VPWR sky130_fd_sc_hd__fill_1
XFILLER_33_202 VGND VGND VPWR VPWR sky130_fd_sc_hd__decap_6
XFILLER_73_393 VGND VGND VPWR VPWR sky130_fd_sc_hd__decap_3
XTAP_TAPCELL_ROW_44_731 VGND VPWR sky130_fd_sc_hd__tapvpwrvgnd_1
XFILLER_33_257 VGND VGND VPWR VPWR sky130_fd_sc_hd__decap_6
X_3700_ _3720_/B _3721_/C _3721_/D _5861_/Q VGND VGND VPWR VPWR _3701_/D sky130_fd_sc_hd__or4b_1
X_4680_ _4688_/B2 _4679_/X _4678_/X _4720_/C1 VGND VGND VPWR VPWR _4680_/X sky130_fd_sc_hd__a211o_1
XFILLER_14_493 VGND VGND VPWR VPWR sky130_fd_sc_hd__fill_1
X_3631_ _3651_/B _5969_/Q VGND VGND VPWR VPWR _3632_/C sky130_fd_sc_hd__xnor2_1
X_3562_ _3544_/X _3562_/B _3562_/C _3562_/D VGND VGND VPWR VPWR _3563_/B sky130_fd_sc_hd__and4b_1
X_5301_ _5301_/A _5301_/B _5301_/C VGND VGND VPWR VPWR _5303_/A sky130_fd_sc_hd__and3_1
XANTENNA__5952__RESET_B fanout334/X VGND VGND VPWR VPWR sky130_fd_sc_hd__diode_2
X_3493_ _6123_/D _3517_/B _3492_/X _6144_/D VGND VGND VPWR VPWR _3530_/B sky130_fd_sc_hd__a22oi_1
XANTENNA__4686__B1 _4686_/B1 VGND VGND VPWR VPWR sky130_fd_sc_hd__diode_2
X_5232_ _6133_/Q _5235_/B _5231_/B _5230_/X _5231_/X VGND VGND VPWR VPWR _6133_/D
+ sky130_fd_sc_hd__a221o_1
Xclkbuf_leaf_5_clk clkload0/A VGND VGND VPWR VPWR clkload7/A sky130_fd_sc_hd__clkbuf_8
X_5163_ hold189/X _5473_/Q _5167_/S VGND VGND VPWR VPWR _6085_/D sky130_fd_sc_hd__mux2_1
X_4114_ _5581_/Q _4114_/B VGND VGND VPWR VPWR _4115_/C sky130_fd_sc_hd__xor2_1
X_5094_ hold216/X _5094_/A1 _5098_/S VGND VGND VPWR VPWR _6017_/D sky130_fd_sc_hd__mux2_1
X_4045_ _4074_/S1 _4045_/B VGND VGND VPWR VPWR _4045_/X sky130_fd_sc_hd__and2b_1
XANTENNA_fanout251_A _4813_/A1 VGND VGND VPWR VPWR sky130_fd_sc_hd__diode_2
XFILLER_37_596 VGND VGND VPWR VPWR sky130_fd_sc_hd__fill_2
XANTENNA_fanout349_A fanout351/X VGND VGND VPWR VPWR sky130_fd_sc_hd__diode_2
X_5996_ _6088_/CLK _5996_/D fanout340/X VGND VGND VPWR VPWR _5996_/Q sky130_fd_sc_hd__dfrtp_1
XFILLER_12_419 VGND VGND VPWR VPWR sky130_fd_sc_hd__fill_1
XANTENNA__6058__RESET_B fanout283/X VGND VGND VPWR VPWR sky130_fd_sc_hd__diode_2
X_4947_ _4679_/X _4947_/A2 _4947_/B1 _4946_/X VGND VGND VPWR VPWR _4947_/X sky130_fd_sc_hd__a22o_1
XANTENNA__4610__A0 _5493_/Q VGND VGND VPWR VPWR sky130_fd_sc_hd__diode_2
X_4878_ _4878_/A _4878_/B VGND VGND VPWR VPWR _4878_/Y sky130_fd_sc_hd__nor2_2
XTAP_TAPCELL_ROW_22_458 VGND VPWR sky130_fd_sc_hd__tapvpwrvgnd_1
XFILLER_20_474 VGND VGND VPWR VPWR sky130_fd_sc_hd__fill_2
X_3829_ _5412_/A _4175_/D _3828_/Y VGND VGND VPWR VPWR _3829_/X sky130_fd_sc_hd__o21ba_1
XANTENNA__5166__A1 _5726_/Q VGND VGND VPWR VPWR sky130_fd_sc_hd__diode_2
XTAP_TAPCELL_ROW_76_1132 VGND VPWR sky130_fd_sc_hd__tapvpwrvgnd_1
XFILLER_47_316 VGND VGND VPWR VPWR sky130_fd_sc_hd__fill_1
XFILLER_74_124 VPWR VGND VPWR VGND sky130_ef_sc_hd__decap_12
XFILLER_70_363 VGND VGND VPWR VPWR sky130_fd_sc_hd__fill_1
XANTENNA__3404__A1 _5521_/Q VGND VGND VPWR VPWR sky130_fd_sc_hd__diode_2
XANTENNA__4601__B1 _4600_/X VGND VGND VPWR VPWR sky130_fd_sc_hd__diode_2
XFILLER_15_279 VGND VGND VPWR VPWR sky130_fd_sc_hd__fill_1
XFILLER_43_599 VGND VGND VPWR VPWR sky130_fd_sc_hd__fill_1
XANTENNA_clkbuf_leaf_34_clk_A clkload2/A VGND VGND VPWR VPWR sky130_fd_sc_hd__diode_2
XANTENNA__5157__A1 _5467_/Q VGND VGND VPWR VPWR sky130_fd_sc_hd__diode_2
XFILLER_7_445 VGND VGND VPWR VPWR sky130_fd_sc_hd__decap_3
XANTENNA_clkbuf_leaf_49_clk_A clkload0/A VGND VGND VPWR VPWR sky130_fd_sc_hd__diode_2
XFILLER_3_673 VPWR VGND VPWR VGND sky130_ef_sc_hd__decap_12
XANTENNA__4668__B1 _4243_/S VGND VGND VPWR VPWR sky130_fd_sc_hd__diode_2
XANTENNA__4439__A _4444_/B VGND VGND VPWR VPWR sky130_fd_sc_hd__diode_2
XFILLER_65_113 VGND VGND VPWR VPWR sky130_fd_sc_hd__decap_4
XFILLER_66_669 VGND VGND VPWR VPWR sky130_fd_sc_hd__fill_1
XFILLER_0_53 VGND VGND VPWR VPWR sky130_fd_sc_hd__decap_3
XANTENNA__4840__A0 _5524_/Q VGND VGND VPWR VPWR sky130_fd_sc_hd__diode_2
XFILLER_34_533 VGND VGND VPWR VPWR sky130_fd_sc_hd__fill_1
XANTENNA__6151__RESET_B fanout310/X VGND VGND VPWR VPWR sky130_fd_sc_hd__diode_2
XFILLER_0_97 VPWR VGND VPWR VGND sky130_ef_sc_hd__decap_12
X_5850_ _6026_/CLK _5850_/D fanout277/X VGND VGND VPWR VPWR _5850_/Q sky130_fd_sc_hd__dfrtp_1
X_4801_ _5473_/Q hold344/X _4805_/S VGND VGND VPWR VPWR _5838_/D sky130_fd_sc_hd__mux2_1
X_5781_ _5942_/CLK _5781_/D fanout296/X VGND VGND VPWR VPWR _5781_/Q sky130_fd_sc_hd__dfrtp_1
X_2993_ _2993_/A _6062_/Q _4978_/C _2993_/D VGND VGND VPWR VPWR _2993_/X sky130_fd_sc_hd__and4_2
X_4732_ _5965_/Q _4740_/A2 _5123_/B _5932_/Q _4731_/X VGND VGND VPWR VPWR _4732_/X
+ sky130_fd_sc_hd__a221o_1
XANTENNA__5148__A1 _5524_/Q VGND VGND VPWR VPWR sky130_fd_sc_hd__diode_2
X_4663_ _5923_/Q _5764_/Q _4679_/S VGND VGND VPWR VPWR _4663_/X sky130_fd_sc_hd__mux2_1
X_3614_ _4428_/A _6053_/Q VGND VGND VPWR VPWR _3715_/C sky130_fd_sc_hd__and2_1
X_4594_ _5491_/Q _5797_/Q _4610_/S VGND VGND VPWR VPWR _4594_/X sky130_fd_sc_hd__mux2_1
X_3545_ _3545_/A _3545_/B VGND VGND VPWR VPWR _3545_/X sky130_fd_sc_hd__or2_1
XFILLER_0_109 VGND VGND VPWR VPWR sky130_fd_sc_hd__decap_3
X_3476_ _5217_/A _3475_/A _4350_/B _3472_/A VGND VGND VPWR VPWR _3479_/B sky130_fd_sc_hd__a211o_1
XANTENNA__4659__B1 _4667_/B1 VGND VGND VPWR VPWR sky130_fd_sc_hd__diode_2
X_5215_ _5230_/B _5205_/X _3663_/A VGND VGND VPWR VPWR _5217_/B sky130_fd_sc_hd__o21a_1
X_6195_ _6195_/A VGND VGND VPWR VPWR uio_oe[4] sky130_fd_sc_hd__buf_2
XTAP_TAPCELL_ROW_71_1062 VGND VPWR sky130_fd_sc_hd__tapvpwrvgnd_1
XANTENNA__4349__A _5187_/B VGND VGND VPWR VPWR sky130_fd_sc_hd__diode_2
XTAP_TAPCELL_ROW_71_1073 VGND VPWR sky130_fd_sc_hd__tapvpwrvgnd_1
X_5146_ hold231/X _5522_/Q _5166_/S VGND VGND VPWR VPWR _6068_/D sky130_fd_sc_hd__mux2_1
X_5077_ hold196/X _5488_/Q _5097_/S VGND VGND VPWR VPWR _6000_/D sky130_fd_sc_hd__mux2_1
X_4028_ hold11/A _4028_/B VGND VGND VPWR VPWR _4028_/Y sky130_fd_sc_hd__nor2_1
XTAP_TAPCELL_ROW_27_517 VGND VPWR sky130_fd_sc_hd__tapvpwrvgnd_1
XANTENNA__4831__B1 _3783_/A VGND VGND VPWR VPWR sky130_fd_sc_hd__diode_2
XANTENNA_fanout254_X _4873_/A VGND VGND VPWR VPWR sky130_fd_sc_hd__diode_2
X_5979_ _6110_/CLK _5979_/D fanout301/X VGND VGND VPWR VPWR _5979_/Q sky130_fd_sc_hd__dfrtp_1
XFILLER_60_47 VPWR VGND VPWR VGND sky130_ef_sc_hd__decap_12
XANTENNA__4347__C1 _5353_/B VGND VGND VPWR VPWR sky130_fd_sc_hd__diode_2
XFILLER_20_282 VGND VGND VPWR VPWR sky130_fd_sc_hd__fill_1
XANTENNA__4898__A0 _5799_/Q VGND VGND VPWR VPWR sky130_fd_sc_hd__diode_2
XANTENNA__4958__S _4973_/S VGND VGND VPWR VPWR sky130_fd_sc_hd__diode_2
XANTENNA__2986__B _4232_/S VGND VGND VPWR VPWR sky130_fd_sc_hd__diode_2
XTAP_TAPCELL_ROW_7_264 VGND VPWR sky130_fd_sc_hd__tapvpwrvgnd_1
XFILLER_48_647 VGND VGND VPWR VPWR sky130_fd_sc_hd__fill_1
XFILLER_16_566 VPWR VGND VPWR VGND sky130_ef_sc_hd__decap_12
XANTENNA__4889__A0 _5796_/Q VGND VGND VPWR VPWR sky130_fd_sc_hd__diode_2
Xhold209 _5514_/Q VGND VGND VPWR VPWR hold209/X sky130_fd_sc_hd__dlygate4sd3_1
X_3330_ _5369_/A _4551_/B _3747_/C VGND VGND VPWR VPWR _3330_/X sky130_fd_sc_hd__and3_1
X_5000_ _4581_/X _5024_/A2 _5024_/B1 _4910_/X VGND VGND VPWR VPWR _5000_/X sky130_fd_sc_hd__a22o_1
X_3261_ _3565_/A _3454_/C _4342_/B VGND VGND VPWR VPWR _3930_/C sky130_fd_sc_hd__or3_4
XFILLER_22_3 VPWR VGND VPWR VGND sky130_ef_sc_hd__decap_12
X_3192_ _5866_/Q _3192_/B VGND VGND VPWR VPWR _3192_/X sky130_fd_sc_hd__or2_1
XFILLER_39_658 VGND VGND VPWR VPWR sky130_fd_sc_hd__decap_4
XFILLER_19_393 VGND VGND VPWR VPWR sky130_fd_sc_hd__decap_3
X_5902_ _6107_/CLK _5902_/D fanout273/X VGND VGND VPWR VPWR _5902_/Q sky130_fd_sc_hd__dfrtp_1
X_5833_ _6088_/CLK _5833_/D fanout339/X VGND VGND VPWR VPWR _5833_/Q sky130_fd_sc_hd__dfrtp_1
XTAP_TAPCELL_ROW_52_829 VGND VPWR sky130_fd_sc_hd__tapvpwrvgnd_1
XFILLER_10_709 VGND VGND VPWR VPWR sky130_fd_sc_hd__decap_4
XANTENNA__3947__S _5353_/A VGND VGND VPWR VPWR sky130_fd_sc_hd__diode_2
XANTENNA__3919__A2 _3240_/B VGND VGND VPWR VPWR sky130_fd_sc_hd__diode_2
X_2976_ _2977_/A _2980_/A _3129_/B VGND VGND VPWR VPWR _3144_/B sky130_fd_sc_hd__and3b_2
XTAP_TAPCELL_ROW_32_575 VGND VPWR sky130_fd_sc_hd__tapvpwrvgnd_1
X_5764_ _6111_/CLK _5764_/D fanout327/X VGND VGND VPWR VPWR _5764_/Q sky130_fd_sc_hd__dfrtp_4
X_4715_ _5930_/Q _4747_/A2 _4747_/B1 _4714_/X VGND VGND VPWR VPWR _4715_/X sky130_fd_sc_hd__a22o_1
XANTENNA__4351__B _4475_/B VGND VGND VPWR VPWR sky130_fd_sc_hd__diode_2
XTAP_TAPCELL_ROW_32_586 VGND VPWR sky130_fd_sc_hd__tapvpwrvgnd_1
X_5695_ _5696_/CLK _5695_/D VGND VGND VPWR VPWR hold76/A sky130_fd_sc_hd__dfxtp_1
X_4646_ _4686_/A1 _4645_/X _4678_/C1 VGND VGND VPWR VPWR _4646_/X sky130_fd_sc_hd__o21a_1
X_4577_ hold261/X _4737_/A2 _4576_/X VGND VGND VPWR VPWR _5770_/D sky130_fd_sc_hd__o21a_1
XFILLER_1_429 VPWR VGND VPWR VGND sky130_ef_sc_hd__decap_12
X_3528_ _3502_/Y _3528_/B _3528_/C VGND VGND VPWR VPWR _3528_/X sky130_fd_sc_hd__and3b_1
X_3459_ _5235_/B _3459_/B VGND VGND VPWR VPWR _3932_/B sky130_fd_sc_hd__nor2_1
XTAP_TAPCELL_ROW_4_234 VGND VPWR sky130_fd_sc_hd__tapvpwrvgnd_1
X_5129_ hold255/X _4424_/A _5137_/S VGND VGND VPWR VPWR _6052_/D sky130_fd_sc_hd__mux2_1
XPHY_EDGE_ROW_24_Left_105 VGND VGND VPWR VPWR sky130_fd_sc_hd__decap_3
XFILLER_29_135 VGND VGND VPWR VPWR sky130_fd_sc_hd__decap_3
XFILLER_45_606 VGND VGND VPWR VPWR sky130_fd_sc_hd__decap_8
XANTENNA__2798__A_N _2895_/A VGND VGND VPWR VPWR sky130_fd_sc_hd__diode_2
XANTENNA__4804__A0 _2843_/B VGND VGND VPWR VPWR sky130_fd_sc_hd__diode_2
XANTENNA__4568__C1 _4704_/C1 VGND VGND VPWR VPWR sky130_fd_sc_hd__diode_2
XANTENNA__4542__A _4542_/A VGND VGND VPWR VPWR sky130_fd_sc_hd__diode_2
XFILLER_71_57 VGND VGND VPWR VPWR sky130_fd_sc_hd__decap_3
XPHY_EDGE_ROW_33_Left_114 VGND VGND VPWR VPWR sky130_fd_sc_hd__decap_3
XFILLER_4_212 VGND VGND VPWR VPWR sky130_fd_sc_hd__decap_3
XANTENNA__2897__A2 _2886_/B VGND VGND VPWR VPWR sky130_fd_sc_hd__diode_2
XFILLER_20_83 VGND VGND VPWR VPWR sky130_fd_sc_hd__fill_1
XFILLER_0_473 VGND VGND VPWR VPWR sky130_fd_sc_hd__decap_3
XPHY_EDGE_ROW_42_Left_123 VGND VGND VPWR VPWR sky130_fd_sc_hd__decap_3
Xhold92 hold92/A VGND VGND VPWR VPWR hold92/X sky130_fd_sc_hd__dlygate4sd3_1
Xhold81 hold81/A VGND VGND VPWR VPWR hold81/X sky130_fd_sc_hd__dlygate4sd3_1
Xhold70 hold70/A VGND VGND VPWR VPWR hold70/X sky130_fd_sc_hd__dlygate4sd3_1
XANTENNA__5048__A0 _2744_/A VGND VGND VPWR VPWR sky130_fd_sc_hd__diode_2
XFILLER_16_363 VGND VGND VPWR VPWR sky130_fd_sc_hd__fill_1
X_2830_ _2833_/A _2934_/A _2830_/C VGND VGND VPWR VPWR _2939_/B sky130_fd_sc_hd__or3_1
XPHY_EDGE_ROW_51_Left_132 VGND VGND VPWR VPWR sky130_fd_sc_hd__decap_3
XANTENNA__4452__A _4452_/A VGND VGND VPWR VPWR sky130_fd_sc_hd__diode_2
X_2761_ _5700_/Q VGND VGND VPWR VPWR _2774_/A sky130_fd_sc_hd__inv_2
X_5480_ _5635_/CLK _5480_/D VGND VGND VPWR VPWR hold44/A sky130_fd_sc_hd__dfxtp_1
X_4500_ _4436_/S _4497_/X _4499_/Y _4462_/A VGND VGND VPWR VPWR _4500_/X sky130_fd_sc_hd__o211a_1
X_4431_ _4447_/A _4444_/C VGND VGND VPWR VPWR _4431_/X sky130_fd_sc_hd__or2_1
XANTENNA__2888__A2 _2917_/A2 VGND VGND VPWR VPWR sky130_fd_sc_hd__diode_2
X_4362_ _5737_/Q _4439_/B VGND VGND VPWR VPWR _4364_/B sky130_fd_sc_hd__and2_1
X_4293_ _5713_/Q _4265_/X _4292_/X _4252_/X VGND VGND VPWR VPWR _4293_/X sky130_fd_sc_hd__a22o_1
XPHY_EDGE_ROW_60_Left_141 VGND VGND VPWR VPWR sky130_fd_sc_hd__decap_3
X_6101_ _6107_/CLK _6101_/D fanout273/X VGND VGND VPWR VPWR _6101_/Q sky130_fd_sc_hd__dfrtp_1
X_3313_ _3362_/C _3363_/B VGND VGND VPWR VPWR _3349_/C sky130_fd_sc_hd__or2_1
X_3244_ _3470_/A _3495_/A VGND VGND VPWR VPWR _3245_/B sky130_fd_sc_hd__nand2_1
X_6032_ _6032_/CLK _6032_/D fanout299/X VGND VGND VPWR VPWR _6032_/Q sky130_fd_sc_hd__dfrtp_2
XFILLER_79_591 VGND VGND VPWR VPWR sky130_fd_sc_hd__fill_1
X_3175_ hold453/X hold11/A VGND VGND VPWR VPWR _5674_/D sky130_fd_sc_hd__and2b_1
XFILLER_27_617 VGND VGND VPWR VPWR sky130_fd_sc_hd__decap_3
XFILLER_26_149 VPWR VGND VPWR VGND sky130_ef_sc_hd__decap_12
XTAP_TAPCELL_ROW_37_645 VGND VPWR sky130_fd_sc_hd__tapvpwrvgnd_1
XTAP_TAPCELL_ROW_65_998 VGND VPWR sky130_fd_sc_hd__tapvpwrvgnd_1
XTAP_TAPCELL_ROW_65_987 VGND VPWR sky130_fd_sc_hd__tapvpwrvgnd_1
XFILLER_41_119 VGND VGND VPWR VPWR sky130_fd_sc_hd__fill_1
XANTENNA__2812__A2 _2917_/A2 VGND VGND VPWR VPWR sky130_fd_sc_hd__diode_2
XANTENNA_fanout331_A fanout334/X VGND VGND VPWR VPWR sky130_fd_sc_hd__diode_2
X_5816_ _6131_/CLK _5816_/D fanout335/X VGND VGND VPWR VPWR _5816_/Q sky130_fd_sc_hd__dfrtp_1
XTAP_TAPCELL_ROW_17_391 VGND VPWR sky130_fd_sc_hd__tapvpwrvgnd_1
XANTENNA__4362__A _5737_/Q VGND VGND VPWR VPWR sky130_fd_sc_hd__diode_2
XFILLER_22_344 VPWR VGND VPWR VGND sky130_ef_sc_hd__decap_12
XFILLER_22_399 VGND VGND VPWR VPWR sky130_fd_sc_hd__fill_2
X_2959_ _5591_/Q _5676_/Q _2958_/X _5600_/Q VGND VGND VPWR VPWR _2959_/X sky130_fd_sc_hd__a22o_1
X_5747_ clkload6/A _5747_/D fanout280/X VGND VGND VPWR VPWR _5747_/Q sky130_fd_sc_hd__dfrtp_1
X_5678_ _5682_/CLK _5678_/D fanout321/X VGND VGND VPWR VPWR _5678_/Q sky130_fd_sc_hd__dfrtp_1
X_4629_ _5952_/Q _5760_/Q _4679_/S VGND VGND VPWR VPWR _4629_/X sky130_fd_sc_hd__mux2_1
XANTENNA__2879__A2 _2916_/B VGND VGND VPWR VPWR sky130_fd_sc_hd__diode_2
XANTENNA__3828__A1 _2744_/A VGND VGND VPWR VPWR sky130_fd_sc_hd__diode_2
XANTENNA_fanout77_A _4828_/B2 VGND VGND VPWR VPWR sky130_fd_sc_hd__diode_2
XFILLER_66_57 VGND VGND VPWR VPWR sky130_fd_sc_hd__fill_1
XANTENNA__4096__X _4164_/B VGND VGND VPWR VPWR sky130_fd_sc_hd__diode_2
XFILLER_18_639 VGND VGND VPWR VPWR sky130_fd_sc_hd__fill_1
XFILLER_26_661 VGND VGND VPWR VPWR sky130_fd_sc_hd__fill_1
XFILLER_25_182 VGND VGND VPWR VPWR sky130_fd_sc_hd__fill_1
XANTENNA__5368__A _5369_/A VGND VGND VPWR VPWR sky130_fd_sc_hd__diode_2
XFILLER_13_366 VGND VGND VPWR VPWR sky130_fd_sc_hd__decap_8
XANTENNA__4211__S _4232_/S VGND VGND VPWR VPWR sky130_fd_sc_hd__diode_2
XFILLER_0_281 VPWR VGND VPWR VGND sky130_ef_sc_hd__decap_12
XANTENNA__3819__B2 _3783_/A VGND VGND VPWR VPWR sky130_fd_sc_hd__diode_2
XANTENNA__3319__A_N _3905_/A VGND VGND VPWR VPWR sky130_fd_sc_hd__diode_2
XFILLER_64_712 VGND VGND VPWR VPWR sky130_fd_sc_hd__fill_1
X_4980_ _4165_/X _4979_/A _4979_/B _4880_/X VGND VGND VPWR VPWR _4980_/X sky130_fd_sc_hd__a22o_1
XANTENNA__5906__RESET_B fanout307/X VGND VGND VPWR VPWR sky130_fd_sc_hd__diode_2
XANTENNA__3047__A2 _2965_/X VGND VGND VPWR VPWR sky130_fd_sc_hd__diode_2
XTAP_TAPCELL_ROW_34_604 VGND VPWR sky130_fd_sc_hd__tapvpwrvgnd_1
XFILLER_63_299 VGND VGND VPWR VPWR sky130_fd_sc_hd__fill_1
XTAP_TAPCELL_ROW_62_957 VGND VPWR sky130_fd_sc_hd__tapvpwrvgnd_1
X_3931_ _3953_/B _3240_/B _3928_/X VGND VGND VPWR VPWR _5590_/D sky130_fd_sc_hd__a21bo_1
X_3862_ _4331_/A1 _3883_/C _3860_/Y _3861_/X _3759_/S VGND VGND VPWR VPWR _3862_/X
+ sky130_fd_sc_hd__o311a_1
X_2813_ _6075_/Q _2786_/X _2926_/B1 _6067_/Q VGND VGND VPWR VPWR _2813_/X sky130_fd_sc_hd__a22o_1
XTAP_TAPCELL_ROW_14_350 VGND VPWR sky130_fd_sc_hd__tapvpwrvgnd_1
XTAP_TAPCELL_ROW_14_361 VGND VPWR sky130_fd_sc_hd__tapvpwrvgnd_1
X_5601_ _5697_/CLK _5601_/D fanout319/X VGND VGND VPWR VPWR _5601_/Q sky130_fd_sc_hd__dfrtp_1
X_5532_ _5645_/CLK _5532_/D VGND VGND VPWR VPWR hold19/A sky130_fd_sc_hd__dfxtp_1
X_3793_ _5506_/Q _3913_/B VGND VGND VPWR VPWR _3793_/X sky130_fd_sc_hd__or2_1
X_2744_ _2744_/A VGND VGND VPWR VPWR _4452_/A sky130_fd_sc_hd__inv_2
XFILLER_8_392 VGND VGND VPWR VPWR sky130_fd_sc_hd__decap_8
XANTENNA__4704__C1 _4704_/C1 VGND VGND VPWR VPWR sky130_fd_sc_hd__diode_2
X_4414_ _4424_/A _4439_/B VGND VGND VPWR VPWR _4430_/A sky130_fd_sc_hd__or2_1
X_5394_ _5390_/X _5402_/A VGND VGND VPWR VPWR _5395_/B sky130_fd_sc_hd__and2b_1
Xfanout305 fanout306/X VGND VGND VPWR VPWR fanout305/X sky130_fd_sc_hd__clkbuf_4
X_4345_ _4452_/B VGND VGND VPWR VPWR _4399_/B sky130_fd_sc_hd__inv_2
Xfanout338 fanout341/X VGND VGND VPWR VPWR fanout338/X sky130_fd_sc_hd__clkbuf_2
Xfanout316 fanout317/X VGND VGND VPWR VPWR fanout316/X sky130_fd_sc_hd__clkbuf_4
Xfanout327 fanout328/X VGND VGND VPWR VPWR fanout327/X sky130_fd_sc_hd__clkbuf_4
Xfanout349 fanout351/X VGND VGND VPWR VPWR fanout349/X sky130_fd_sc_hd__clkbuf_4
X_4276_ hold388/X _4275_/X _4312_/S VGND VGND VPWR VPWR _5711_/D sky130_fd_sc_hd__mux2_1
X_6015_ _6092_/CLK _6015_/D fanout342/X VGND VGND VPWR VPWR _6015_/Q sky130_fd_sc_hd__dfrtp_1
X_3227_ _4967_/A0 _5492_/Q _3229_/S VGND VGND VPWR VPWR _5492_/D sky130_fd_sc_hd__mux2_1
XANTENNA__4357__A _5353_/B VGND VGND VPWR VPWR sky130_fd_sc_hd__diode_2
XANTENNA_fanout281_A fanout287/X VGND VGND VPWR VPWR sky130_fd_sc_hd__diode_2
X_3158_ _5915_/Q _2988_/B _3127_/B VGND VGND VPWR VPWR _3158_/X sky130_fd_sc_hd__a21o_1
XTAP_TAPCELL_ROW_68_1034 VGND VPWR sky130_fd_sc_hd__tapvpwrvgnd_1
XANTENNA__4791__S _4805_/S VGND VGND VPWR VPWR sky130_fd_sc_hd__diode_2
X_3089_ _5677_/Q _5678_/Q _4014_/A VGND VGND VPWR VPWR _3089_/Y sky130_fd_sc_hd__a21oi_1
XFILLER_52_15 VPWR VGND VPWR VGND sky130_ef_sc_hd__decap_12
XANTENNA__5188__A _5353_/B VGND VGND VPWR VPWR sky130_fd_sc_hd__diode_2
XANTENNA_fanout334_X fanout334/X VGND VGND VPWR VPWR sky130_fd_sc_hd__diode_2
XANTENNA__3200__S _3203_/S VGND VGND VPWR VPWR sky130_fd_sc_hd__diode_2
XFILLER_22_141 VGND VGND VPWR VPWR sky130_fd_sc_hd__fill_1
XANTENNA__4538__A2 _4475_/B VGND VGND VPWR VPWR sky130_fd_sc_hd__diode_2
XFILLER_22_163 VGND VGND VPWR VPWR sky130_fd_sc_hd__fill_2
XFILLER_22_185 VGND VGND VPWR VPWR sky130_fd_sc_hd__fill_1
XFILLER_6_307 VGND VGND VPWR VPWR sky130_fd_sc_hd__fill_1
XTAP_TAPCELL_ROW_79_1163 VGND VPWR sky130_fd_sc_hd__tapvpwrvgnd_1
Xhold381 _5866_/Q VGND VGND VPWR VPWR hold381/X sky130_fd_sc_hd__dlygate4sd3_1
Xhold370 _6166_/Q VGND VGND VPWR VPWR hold370/X sky130_fd_sc_hd__dlygate4sd3_1
XFILLER_77_45 VGND VGND VPWR VPWR sky130_fd_sc_hd__decap_4
Xhold392 _5647_/Q VGND VGND VPWR VPWR hold392/X sky130_fd_sc_hd__dlygate4sd3_1
XFILLER_46_701 VGND VGND VPWR VPWR sky130_fd_sc_hd__fill_1
XFILLER_46_712 VGND VGND VPWR VPWR sky130_fd_sc_hd__fill_1
XFILLER_18_469 VGND VGND VPWR VPWR sky130_fd_sc_hd__decap_6
XFILLER_33_417 VPWR VGND VPWR VGND sky130_ef_sc_hd__decap_12
XANTENNA__4777__A2 _3905_/B VGND VGND VPWR VPWR sky130_fd_sc_hd__diode_2
XFILLER_13_152 VGND VGND VPWR VPWR sky130_fd_sc_hd__fill_2
XFILLER_41_483 VGND VGND VPWR VPWR sky130_fd_sc_hd__fill_1
XTAP_TAPCELL_ROW_11_320 VGND VPWR sky130_fd_sc_hd__tapvpwrvgnd_1
XFILLER_9_167 VGND VGND VPWR VPWR sky130_fd_sc_hd__fill_1
XANTENNA__6176__RESET_B fanout286/X VGND VGND VPWR VPWR sky130_fd_sc_hd__diode_2
X_4130_ _4130_/A _4130_/B _4130_/C _4130_/D VGND VGND VPWR VPWR _4148_/C sky130_fd_sc_hd__or4_1
XANTENNA__4465__A1 _4452_/A VGND VGND VPWR VPWR sky130_fd_sc_hd__diode_2
X_4061_ hold137/X _3975_/Y _4059_/X _4060_/X VGND VGND VPWR VPWR _5664_/D sky130_fd_sc_hd__a22o_1
X_3012_ _3010_/X _3011_/X _3953_/B VGND VGND VPWR VPWR _3012_/X sky130_fd_sc_hd__mux2_1
XFILLER_37_712 VGND VGND VPWR VPWR sky130_fd_sc_hd__fill_1
XTAP_TAPCELL_ROW_19_420 VGND VPWR sky130_fd_sc_hd__tapvpwrvgnd_1
XTAP_TAPCELL_ROW_47_773 VGND VPWR sky130_fd_sc_hd__tapvpwrvgnd_1
XFILLER_36_277 VPWR VGND VPWR VGND sky130_ef_sc_hd__decap_12
XTAP_TAPCELL_ROW_47_762 VGND VPWR sky130_fd_sc_hd__tapvpwrvgnd_1
X_4963_ hold425/X _4972_/A2 _4962_/X VGND VGND VPWR VPWR _5930_/D sky130_fd_sc_hd__a21o_1
XFILLER_51_214 VGND VGND VPWR VPWR sky130_fd_sc_hd__decap_8
X_3914_ _5815_/Q _3879_/S _3913_/X _4109_/C VGND VGND VPWR VPWR _3914_/X sky130_fd_sc_hd__o211a_1
X_4894_ _5907_/Q _4972_/A2 _4893_/X VGND VGND VPWR VPWR _5907_/D sky130_fd_sc_hd__a21o_1
XFILLER_20_612 VGND VGND VPWR VPWR sky130_fd_sc_hd__fill_1
X_3845_ _6171_/Q _3845_/B _3893_/C VGND VGND VPWR VPWR _3845_/X sky130_fd_sc_hd__and3_1
X_3776_ _5569_/Q _3759_/S _3773_/Y _3775_/Y VGND VGND VPWR VPWR _5569_/D sky130_fd_sc_hd__o22a_1
XANTENNA_fanout127_A _4877_/X VGND VGND VPWR VPWR sky130_fd_sc_hd__diode_2
XFILLER_20_689 VGND VGND VPWR VPWR sky130_fd_sc_hd__fill_1
X_2727_ _5465_/Q VGND VGND VPWR VPWR _3426_/A sky130_fd_sc_hd__inv_2
X_5515_ clkload5/A _5515_/D fanout277/X VGND VGND VPWR VPWR _5515_/Q sky130_fd_sc_hd__dfrtp_1
X_5446_ _5447_/A _5453_/B VGND VGND VPWR VPWR _5446_/X sky130_fd_sc_hd__and2_1
Xfanout102 _5025_/A2 VGND VGND VPWR VPWR _5041_/A2 sky130_fd_sc_hd__buf_2
Xfanout113 _4344_/A VGND VGND VPWR VPWR _5362_/B sky130_fd_sc_hd__buf_2
X_5377_ _5377_/A _5453_/B VGND VGND VPWR VPWR _5378_/B sky130_fd_sc_hd__nor2_1
Xfanout146 _4876_/Y VGND VGND VPWR VPWR _4947_/A2 sky130_fd_sc_hd__clkbuf_2
X_4328_ _5723_/Q _4157_/A _4325_/X _4331_/A1 VGND VGND VPWR VPWR _5723_/D sky130_fd_sc_hd__a22o_1
Xfanout124 _4978_/X VGND VGND VPWR VPWR _5026_/B1 sky130_fd_sc_hd__buf_2
XANTENNA_input1_A rst_n VGND VGND VPWR VPWR sky130_fd_sc_hd__diode_2
Xfanout168 _2967_/X VGND VGND VPWR VPWR _4615_/S sky130_fd_sc_hd__buf_2
XFILLER_59_369 VGND VGND VPWR VPWR sky130_fd_sc_hd__decap_8
X_4259_ _5566_/Q _5574_/Q _4277_/S VGND VGND VPWR VPWR _4259_/X sky130_fd_sc_hd__mux2_1
Xfanout179 fanout179/A VGND VGND VPWR VPWR _2928_/A2 sky130_fd_sc_hd__clkbuf_2
Xfanout157 _3970_/X VGND VGND VPWR VPWR _3976_/B sky130_fd_sc_hd__buf_1
XFILLER_27_277 VGND VGND VPWR VPWR sky130_fd_sc_hd__decap_3
XFILLER_42_269 VGND VGND VPWR VPWR sky130_fd_sc_hd__fill_1
XTAP_TAPCELL_ROW_25_489 VGND VPWR sky130_fd_sc_hd__tapvpwrvgnd_1
XFILLER_77_111 VGND VGND VPWR VPWR sky130_fd_sc_hd__fill_1
XANTENNA_clkbuf_leaf_8_clk_A clkbuf_leaf_9_clk/A VGND VGND VPWR VPWR sky130_fd_sc_hd__diode_2
XFILLER_65_339 VGND VGND VPWR VPWR sky130_fd_sc_hd__decap_4
XANTENNA__4998__A2 _5024_/A2 VGND VGND VPWR VPWR sky130_fd_sc_hd__diode_2
XFILLER_80_309 VGND VGND VPWR VPWR sky130_fd_sc_hd__fill_1
XANTENNA__4444__B _4444_/B VGND VGND VPWR VPWR sky130_fd_sc_hd__diode_2
XFILLER_33_225 VGND VGND VPWR VPWR sky130_fd_sc_hd__decap_6
XTAP_TAPCELL_ROW_44_732 VGND VPWR sky130_fd_sc_hd__tapvpwrvgnd_1
X_3630_ _4447_/B _5971_/Q VGND VGND VPWR VPWR _3632_/B sky130_fd_sc_hd__xnor2_1
X_3561_ _3549_/A _3547_/Y _3560_/X _3545_/X VGND VGND VPWR VPWR _3562_/B sky130_fd_sc_hd__o211a_1
XFILLER_52_3 VPWR VGND VPWR VGND sky130_ef_sc_hd__decap_12
X_5300_ _5300_/A VGND VGND VPWR VPWR _5301_/C sky130_fd_sc_hd__inv_2
XFILLER_5_181 VGND VGND VPWR VPWR sky130_fd_sc_hd__fill_2
X_3492_ _3550_/A _3492_/B _3459_/B VGND VGND VPWR VPWR _3492_/X sky130_fd_sc_hd__or3b_4
XANTENNA__4686__A1 _4686_/A1 VGND VGND VPWR VPWR sky130_fd_sc_hd__diode_2
X_5231_ _5231_/A _5231_/B VGND VGND VPWR VPWR _5231_/X sky130_fd_sc_hd__and2_1
XFILLER_69_634 VGND VGND VPWR VPWR sky130_fd_sc_hd__fill_1
X_5162_ hold154/X _5472_/Q _5166_/S VGND VGND VPWR VPWR _6084_/D sky130_fd_sc_hd__mux2_1
XANTENNA__5992__RESET_B fanout341/X VGND VGND VPWR VPWR sky130_fd_sc_hd__diode_2
X_4113_ _5567_/Q _4113_/B VGND VGND VPWR VPWR _4115_/B sky130_fd_sc_hd__xor2_1
X_5093_ hold237/X _5726_/Q _5097_/S VGND VGND VPWR VPWR _6016_/D sky130_fd_sc_hd__mux2_1
XFILLER_68_188 VGND VGND VPWR VPWR sky130_fd_sc_hd__decap_8
X_4044_ hold22/A hold31/A _4070_/S VGND VGND VPWR VPWR _4045_/B sky130_fd_sc_hd__mux2_1
XFILLER_71_309 VGND VGND VPWR VPWR sky130_fd_sc_hd__fill_1
XANTENNA__2853__B1_N _2797_/X VGND VGND VPWR VPWR sky130_fd_sc_hd__diode_2
X_5995_ _6091_/CLK _5995_/D fanout347/X VGND VGND VPWR VPWR _5995_/Q sky130_fd_sc_hd__dfrtp_1
XFILLER_40_707 VGND VGND VPWR VPWR sky130_fd_sc_hd__decap_6
X_4946_ _5473_/Q _4674_/X _4949_/S VGND VGND VPWR VPWR _4946_/X sky130_fd_sc_hd__mux2_1
XANTENNA__4610__A1 _5799_/Q VGND VGND VPWR VPWR sky130_fd_sc_hd__diode_2
XANTENNA_fanout244_A _4447_/B VGND VGND VPWR VPWR sky130_fd_sc_hd__diode_2
XANTENNA__4071__C1 _4542_/A VGND VGND VPWR VPWR sky130_fd_sc_hd__diode_2
XTAP_TAPCELL_ROW_22_459 VGND VPWR sky130_fd_sc_hd__tapvpwrvgnd_1
X_4877_ _6097_/Q _4978_/C _4978_/D _6062_/Q VGND VGND VPWR VPWR _4877_/X sky130_fd_sc_hd__and4b_2
XFILLER_20_464 VGND VGND VPWR VPWR sky130_fd_sc_hd__fill_1
X_3828_ _2744_/A _4762_/C _3827_/X _3845_/B VGND VGND VPWR VPWR _3828_/Y sky130_fd_sc_hd__a211oi_1
XTAP_TAPCELL_ROW_76_1133 VGND VPWR sky130_fd_sc_hd__tapvpwrvgnd_1
X_3759_ _5568_/Q _3758_/X _3759_/S VGND VGND VPWR VPWR _5568_/D sky130_fd_sc_hd__mux2_1
XANTENNA__4677__A1 _5766_/Q VGND VGND VPWR VPWR sky130_fd_sc_hd__diode_2
X_5429_ _5415_/A _5415_/B _5416_/A _5422_/Y VGND VGND VPWR VPWR _5429_/X sky130_fd_sc_hd__o211a_1
XFILLER_59_144 VPWR VGND VPWR VGND sky130_ef_sc_hd__decap_12
XFILLER_58_58 VGND VGND VPWR VPWR sky130_fd_sc_hd__fill_2
XFILLER_74_136 VGND VGND VPWR VPWR sky130_fd_sc_hd__decap_4
XFILLER_28_531 VGND VGND VPWR VPWR sky130_fd_sc_hd__fill_1
XFILLER_74_57 VGND VGND VPWR VPWR sky130_fd_sc_hd__fill_2
XFILLER_28_597 VGND VGND VPWR VPWR sky130_fd_sc_hd__decap_8
XANTENNA__2860__B1 _2927_/B1 VGND VGND VPWR VPWR sky130_fd_sc_hd__diode_2
XANTENNA__5376__A _5377_/A VGND VGND VPWR VPWR sky130_fd_sc_hd__diode_2
XFILLER_3_685 VPWR VGND VPWR VGND sky130_ef_sc_hd__decap_12
XFILLER_78_475 VGND VGND VPWR VPWR sky130_fd_sc_hd__fill_1
XFILLER_65_147 VGND VGND VPWR VPWR sky130_fd_sc_hd__decap_4
XANTENNA__5093__A1 _5726_/Q VGND VGND VPWR VPWR sky130_fd_sc_hd__diode_2
XFILLER_80_106 VGND VGND VPWR VPWR sky130_fd_sc_hd__decap_3
XFILLER_74_670 VGND VGND VPWR VPWR sky130_fd_sc_hd__fill_1
XFILLER_65_169 VGND VGND VPWR VPWR sky130_fd_sc_hd__decap_4
XFILLER_61_320 VGND VGND VPWR VPWR sky130_fd_sc_hd__fill_1
XTAP_TAPCELL_ROW_57_890 VGND VPWR sky130_fd_sc_hd__tapvpwrvgnd_1
XFILLER_34_512 VGND VGND VPWR VPWR sky130_fd_sc_hd__decap_8
XFILLER_34_523 VGND VGND VPWR VPWR sky130_fd_sc_hd__decap_8
X_4800_ _5472_/Q hold309/X _4805_/S VGND VGND VPWR VPWR _5837_/D sky130_fd_sc_hd__mux2_1
X_5780_ _5788_/CLK _5780_/D fanout297/X VGND VGND VPWR VPWR _5780_/Q sky130_fd_sc_hd__dfrtp_1
X_2992_ _2985_/Y _2987_/Y _2988_/Y _2991_/Y VGND VGND VPWR VPWR _2992_/X sky130_fd_sc_hd__a31o_1
XFILLER_34_589 VGND VGND VPWR VPWR sky130_fd_sc_hd__fill_2
XANTENNA__4053__C1 _4542_/A VGND VGND VPWR VPWR sky130_fd_sc_hd__diode_2
X_4731_ _4747_/B1 _4730_/X _4243_/S VGND VGND VPWR VPWR _4731_/X sky130_fd_sc_hd__a21o_1
X_4662_ _4678_/A1 _4661_/X _4686_/B1 VGND VGND VPWR VPWR _4662_/X sky130_fd_sc_hd__o21a_1
X_3613_ _4452_/A _6055_/Q VGND VGND VPWR VPWR _3613_/Y sky130_fd_sc_hd__nor2_1
XANTENNA__6120__RESET_B fanout313/X VGND VGND VPWR VPWR sky130_fd_sc_hd__diode_2
X_4593_ hold184/X _4745_/A2 _4592_/X VGND VGND VPWR VPWR _5772_/D sky130_fd_sc_hd__o21a_1
X_3544_ _3542_/Y _3543_/X _3537_/A _3509_/B VGND VGND VPWR VPWR _3544_/X sky130_fd_sc_hd__a2bb2o_2
X_3475_ _3475_/A _4344_/D VGND VGND VPWR VPWR _3475_/Y sky130_fd_sc_hd__nor2_1
X_5214_ _5228_/A _5213_/X _3663_/A VGND VGND VPWR VPWR _5223_/B sky130_fd_sc_hd__o21ai_1
XTAP_TAPCELL_ROW_71_1063 VGND VPWR sky130_fd_sc_hd__tapvpwrvgnd_1
X_5145_ hold198/X _5521_/Q _5167_/S VGND VGND VPWR VPWR _6067_/D sky130_fd_sc_hd__mux2_1
XANTENNA__5522__Q _5522_/Q VGND VGND VPWR VPWR sky130_fd_sc_hd__diode_2
XFILLER_29_317 VGND VGND VPWR VPWR sky130_fd_sc_hd__fill_2
XANTENNA__5084__A1 _5467_/Q VGND VGND VPWR VPWR sky130_fd_sc_hd__diode_2
X_5076_ hold183/X _5487_/Q _5098_/S VGND VGND VPWR VPWR _5999_/D sky130_fd_sc_hd__mux2_1
X_4027_ _5655_/Q _4027_/B VGND VGND VPWR VPWR _4028_/B sky130_fd_sc_hd__and2_1
XFILLER_44_309 VGND VGND VPWR VPWR sky130_fd_sc_hd__decap_3
XANTENNA__4831__B2 _5719_/Q VGND VGND VPWR VPWR sky130_fd_sc_hd__diode_2
XTAP_TAPCELL_ROW_27_518 VGND VPWR sky130_fd_sc_hd__tapvpwrvgnd_1
X_5978_ clkload3/A _5978_/D fanout276/X VGND VGND VPWR VPWR _5978_/Q sky130_fd_sc_hd__dfrtp_1
XANTENNA_fanout247_X _4427_/A VGND VGND VPWR VPWR sky130_fd_sc_hd__diode_2
XFILLER_40_515 VPWR VGND VPWR VGND sky130_ef_sc_hd__decap_12
X_4929_ _4631_/X _4947_/A2 _4947_/B1 _4928_/X VGND VGND VPWR VPWR _4929_/X sky130_fd_sc_hd__a22o_1
XANTENNA__4595__B1 _4667_/B1 VGND VGND VPWR VPWR sky130_fd_sc_hd__diode_2
XFILLER_60_15 VPWR VGND VPWR VGND sky130_ef_sc_hd__decap_12
XFILLER_60_59 VGND VGND VPWR VPWR sky130_fd_sc_hd__decap_4
XANTENNA__4898__A1 _5523_/Q VGND VGND VPWR VPWR sky130_fd_sc_hd__diode_2
XTAP_TAPCELL_ROW_7_265 VGND VPWR sky130_fd_sc_hd__tapvpwrvgnd_1
XANTENNA__5075__A1 _5524_/Q VGND VGND VPWR VPWR sky130_fd_sc_hd__diode_2
XFILLER_28_361 VGND VGND VPWR VPWR sky130_fd_sc_hd__decap_3
XFILLER_71_651 VGND VGND VPWR VPWR sky130_fd_sc_hd__fill_1
XFILLER_16_556 VGND VGND VPWR VPWR sky130_fd_sc_hd__fill_1
XTAP_TAPCELL_ROW_54_860 VGND VPWR sky130_fd_sc_hd__tapvpwrvgnd_1
XFILLER_16_578 VGND VGND VPWR VPWR sky130_fd_sc_hd__decap_6
XANTENNA__4035__C1 _4542_/A VGND VGND VPWR VPWR sky130_fd_sc_hd__diode_2
XANTENNA__4586__A0 _5490_/Q VGND VGND VPWR VPWR sky130_fd_sc_hd__diode_2
XANTENNA__4214__S _4232_/S VGND VGND VPWR VPWR sky130_fd_sc_hd__diode_2
XANTENNA__3619__A _4428_/A VGND VGND VPWR VPWR sky130_fd_sc_hd__diode_2
XANTENNA__4889__A1 _5520_/Q VGND VGND VPWR VPWR sky130_fd_sc_hd__diode_2
XFILLER_50_81 VGND VGND VPWR VPWR sky130_fd_sc_hd__decap_3
XFILLER_7_298 VGND VGND VPWR VPWR sky130_fd_sc_hd__decap_6
X_3260_ _6125_/Q _6124_/Q _6126_/Q _6127_/Q VGND VGND VPWR VPWR _4342_/B sky130_fd_sc_hd__or4_1
XFILLER_38_103 VGND VGND VPWR VPWR sky130_fd_sc_hd__decap_3
X_3191_ _5864_/Q _5862_/Q VGND VGND VPWR VPWR _3192_/B sky130_fd_sc_hd__or2_4
XFILLER_15_3 VGND VGND VPWR VPWR sky130_fd_sc_hd__decap_8
XFILLER_26_309 VGND VGND VPWR VPWR sky130_fd_sc_hd__decap_4
XANTENNA__5066__A1 _3905_/A VGND VGND VPWR VPWR sky130_fd_sc_hd__diode_2
X_5901_ _6032_/CLK _5901_/D fanout292/X VGND VGND VPWR VPWR _5901_/Q sky130_fd_sc_hd__dfrtp_4
XFILLER_19_361 VGND VGND VPWR VPWR sky130_fd_sc_hd__fill_1
XFILLER_19_383 VGND VGND VPWR VPWR sky130_fd_sc_hd__fill_1
XANTENNA__4813__A1 _4813_/A1 VGND VGND VPWR VPWR sky130_fd_sc_hd__diode_2
XANTENNA__3927__D_N _6128_/D VGND VGND VPWR VPWR sky130_fd_sc_hd__diode_2
X_5832_ _6093_/CLK _5832_/D fanout345/X VGND VGND VPWR VPWR _5832_/Q sky130_fd_sc_hd__dfrtp_1
XFILLER_22_515 VGND VGND VPWR VPWR sky130_fd_sc_hd__fill_1
XANTENNA__4577__B1 _4576_/X VGND VGND VPWR VPWR sky130_fd_sc_hd__diode_2
X_5763_ _6163_/CLK _5763_/D fanout325/X VGND VGND VPWR VPWR _5763_/Q sky130_fd_sc_hd__dfrtp_4
X_4714_ _5796_/Q _2934_/B _4746_/S VGND VGND VPWR VPWR _4714_/X sky130_fd_sc_hd__mux2_1
X_2975_ _5944_/Q _2968_/X _2971_/X _5952_/Q _2974_/X VGND VGND VPWR VPWR _2975_/X
+ sky130_fd_sc_hd__a221o_1
X_5694_ _5697_/CLK _5694_/D VGND VGND VPWR VPWR hold69/A sky130_fd_sc_hd__dfxtp_1
XTAP_TAPCELL_ROW_32_576 VGND VPWR sky130_fd_sc_hd__tapvpwrvgnd_1
XANTENNA__5517__Q _5517_/Q VGND VGND VPWR VPWR sky130_fd_sc_hd__diode_2
X_4645_ _5954_/Q _5762_/Q _4687_/S VGND VGND VPWR VPWR _4645_/X sky130_fd_sc_hd__mux2_1
X_4576_ _4672_/A1 _4575_/X _4574_/X _4704_/C1 VGND VGND VPWR VPWR _4576_/X sky130_fd_sc_hd__a211o_1
X_3527_ _3509_/Y _3546_/B _3525_/X _3508_/X _3506_/X VGND VGND VPWR VPWR _3528_/C
+ sky130_fd_sc_hd__a311o_1
XANTENNA__3264__A _6128_/D VGND VGND VPWR VPWR sky130_fd_sc_hd__diode_2
XANTENNA_clkbuf_leaf_33_clk_A clkload2/A VGND VGND VPWR VPWR sky130_fd_sc_hd__diode_2
X_3458_ _5197_/A _3918_/B _3458_/C VGND VGND VPWR VPWR _3459_/B sky130_fd_sc_hd__and3_1
XFILLER_39_38 VGND VGND VPWR VPWR sky130_fd_sc_hd__fill_1
X_6177_ _3182_/A1 _6177_/D fanout298/X VGND VGND VPWR VPWR _6177_/Q sky130_fd_sc_hd__dfrtp_2
XTAP_TAPCELL_ROW_4_224 VGND VPWR sky130_fd_sc_hd__tapvpwrvgnd_1
XANTENNA_fanout197_X _5369_/A VGND VGND VPWR VPWR sky130_fd_sc_hd__diode_2
X_3389_ hold202/X _3397_/A2 _3725_/B _3388_/X VGND VGND VPWR VPWR _5512_/D sky130_fd_sc_hd__a22o_1
X_5128_ _6051_/Q _5740_/Q _5137_/S VGND VGND VPWR VPWR _6051_/D sky130_fd_sc_hd__mux2_1
XTAP_TAPCELL_ROW_4_235 VGND VPWR sky130_fd_sc_hd__tapvpwrvgnd_1
XFILLER_55_15 VGND VGND VPWR VPWR sky130_fd_sc_hd__decap_8
XFILLER_29_158 VGND VGND VPWR VPWR sky130_fd_sc_hd__fill_1
XANTENNA__5057__A1 _6167_/Q VGND VGND VPWR VPWR sky130_fd_sc_hd__diode_2
XANTENNA__3203__S _3203_/S VGND VGND VPWR VPWR sky130_fd_sc_hd__diode_2
X_5059_ _5983_/Q hold323/X _5123_/B VGND VGND VPWR VPWR _5059_/X sky130_fd_sc_hd__mux2_1
XANTENNA_clkbuf_leaf_48_clk_A clkload1/A VGND VGND VPWR VPWR sky130_fd_sc_hd__diode_2
XANTENNA__4034__S _4052_/S VGND VGND VPWR VPWR sky130_fd_sc_hd__diode_2
XANTENNA__3791__A1 _3651_/B VGND VGND VPWR VPWR sky130_fd_sc_hd__diode_2
XANTENNA__4740__B1 _4740_/B1 VGND VGND VPWR VPWR sky130_fd_sc_hd__diode_2
XFILLER_4_268 VPWR VGND VPWR VGND sky130_ef_sc_hd__decap_12
Xhold71 hold71/A VGND VGND VPWR VPWR hold71/X sky130_fd_sc_hd__dlygate4sd3_1
Xhold60 hold60/A VGND VGND VPWR VPWR hold60/X sky130_fd_sc_hd__dlygate4sd3_1
Xhold82 hold82/A VGND VGND VPWR VPWR hold82/X sky130_fd_sc_hd__dlygate4sd3_1
Xhold93 hold93/A VGND VGND VPWR VPWR hold93/X sky130_fd_sc_hd__dlygate4sd3_1
XANTENNA__2806__B1 _2886_/B VGND VGND VPWR VPWR sky130_fd_sc_hd__diode_2
XFILLER_28_191 VGND VGND VPWR VPWR sky130_fd_sc_hd__decap_4
XFILLER_16_386 VGND VGND VPWR VPWR sky130_fd_sc_hd__fill_2
XANTENNA__4559__B1 _3564_/A VGND VGND VPWR VPWR sky130_fd_sc_hd__diode_2
XANTENNA__3994__D _4005_/S VGND VGND VPWR VPWR sky130_fd_sc_hd__diode_2
X_2760_ _5699_/Q VGND VGND VPWR VPWR _4155_/A sky130_fd_sc_hd__inv_2
X_4430_ _4430_/A _4430_/B _4430_/C VGND VGND VPWR VPWR _4430_/X sky130_fd_sc_hd__and3_1
XANTENNA__4731__B1 _4243_/S VGND VGND VPWR VPWR sky130_fd_sc_hd__diode_2
X_6100_ _6107_/CLK _6100_/D fanout273/X VGND VGND VPWR VPWR _6100_/Q sky130_fd_sc_hd__dfrtp_1
X_4361_ _6109_/Q _5736_/Q _5737_/Q VGND VGND VPWR VPWR _4380_/B sky130_fd_sc_hd__or3_1
X_4292_ _5706_/Q _4291_/X _4310_/S VGND VGND VPWR VPWR _4292_/X sky130_fd_sc_hd__mux2_1
X_3312_ _5986_/Q _5427_/A VGND VGND VPWR VPWR _3363_/B sky130_fd_sc_hd__and2b_1
X_3243_ _4350_/A _3470_/B VGND VGND VPWR VPWR _3495_/A sky130_fd_sc_hd__nor2_1
X_6031_ clkload5/A _6031_/D fanout281/X VGND VGND VPWR VPWR _6031_/Q sky130_fd_sc_hd__dfrtp_1
XFILLER_66_253 VGND VGND VPWR VPWR sky130_fd_sc_hd__decap_3
X_3174_ hold365/X hold78/A VGND VGND VPWR VPWR _5686_/D sky130_fd_sc_hd__and2b_1
XANTENNA__4798__A0 _5470_/Q VGND VGND VPWR VPWR sky130_fd_sc_hd__diode_2
XTAP_TAPCELL_ROW_37_646 VGND VPWR sky130_fd_sc_hd__tapvpwrvgnd_1
XTAP_TAPCELL_ROW_65_988 VGND VPWR sky130_fd_sc_hd__tapvpwrvgnd_1
XFILLER_50_643 VGND VGND VPWR VPWR sky130_fd_sc_hd__fill_1
X_5815_ _6050_/CLK _5815_/D fanout290/X VGND VGND VPWR VPWR _5815_/Q sky130_fd_sc_hd__dfrtp_1
XTAP_TAPCELL_ROW_17_392 VGND VPWR sky130_fd_sc_hd__tapvpwrvgnd_1
XFILLER_22_356 VGND VGND VPWR VPWR sky130_fd_sc_hd__fill_2
XANTENNA__3222__A0 _2824_/C VGND VGND VPWR VPWR sky130_fd_sc_hd__diode_2
XFILLER_10_529 VGND VGND VPWR VPWR sky130_fd_sc_hd__decap_3
X_2958_ _5676_/Q _5565_/Q VGND VGND VPWR VPWR _2958_/X sky130_fd_sc_hd__and2b_2
X_5746_ clkload6/A _5746_/D fanout280/X VGND VGND VPWR VPWR _5746_/Q sky130_fd_sc_hd__dfrtp_1
XANTENNA_fanout324_A input1/X VGND VGND VPWR VPWR sky130_fd_sc_hd__diode_2
XANTENNA__4789__S _4805_/S VGND VGND VPWR VPWR sky130_fd_sc_hd__diode_2
XANTENNA__4970__A0 _4970_/A0 VGND VGND VPWR VPWR sky130_fd_sc_hd__diode_2
X_5677_ _5682_/CLK _5677_/D fanout321/X VGND VGND VPWR VPWR _5677_/Q sky130_fd_sc_hd__dfrtp_2
X_2889_ _2889_/A _2889_/B _2889_/C _2886_/Y VGND VGND VPWR VPWR _2889_/X sky130_fd_sc_hd__or4b_1
X_4628_ _5952_/Q _4683_/A2 _4740_/B1 _4627_/X VGND VGND VPWR VPWR _4628_/X sky130_fd_sc_hd__a211o_1
XANTENNA_fanout112_X _4855_/S VGND VGND VPWR VPWR sky130_fd_sc_hd__diode_2
XANTENNA__4722__A0 _5797_/Q VGND VGND VPWR VPWR sky130_fd_sc_hd__diode_2
X_4559_ _5767_/Q _4761_/A2 _3564_/A _4551_/X VGND VGND VPWR VPWR _5767_/D sky130_fd_sc_hd__a22o_1
XFILLER_1_227 VPWR VGND VPWR VGND sky130_ef_sc_hd__decap_12
XANTENNA__4789__A0 _5489_/Q VGND VGND VPWR VPWR sky130_fd_sc_hd__diode_2
XFILLER_60_429 VGND VGND VPWR VPWR sky130_fd_sc_hd__fill_1
XFILLER_13_334 VGND VGND VPWR VPWR sky130_fd_sc_hd__fill_2
XANTENNA__3461__B1 _5353_/A VGND VGND VPWR VPWR sky130_fd_sc_hd__diode_2
XFILLER_41_665 VGND VGND VPWR VPWR sky130_fd_sc_hd__fill_1
XFILLER_13_389 VGND VGND VPWR VPWR sky130_fd_sc_hd__decap_3
XANTENNA__4961__A0 _2934_/B VGND VGND VPWR VPWR sky130_fd_sc_hd__diode_2
XFILLER_40_197 VGND VGND VPWR VPWR sky130_fd_sc_hd__fill_1
XFILLER_0_293 VPWR VGND VPWR VGND sky130_ef_sc_hd__decap_12
XANTENNA__4447__B _4447_/B VGND VGND VPWR VPWR sky130_fd_sc_hd__diode_2
XANTENNA__4166__C _4166_/C VGND VGND VPWR VPWR sky130_fd_sc_hd__diode_2
XFILLER_63_223 VGND VGND VPWR VPWR sky130_fd_sc_hd__fill_1
XFILLER_36_459 VPWR VGND VPWR VGND sky130_ef_sc_hd__decap_12
XFILLER_17_673 VGND VGND VPWR VPWR sky130_fd_sc_hd__decap_8
X_3930_ _6129_/D _5362_/B _3930_/C _6128_/D VGND VGND VPWR VPWR _3930_/X sky130_fd_sc_hd__or4b_1
XTAP_TAPCELL_ROW_34_605 VGND VPWR sky130_fd_sc_hd__tapvpwrvgnd_1
XTAP_TAPCELL_ROW_62_958 VGND VPWR sky130_fd_sc_hd__tapvpwrvgnd_1
X_3861_ _4102_/B _4102_/C _3758_/S VGND VGND VPWR VPWR _3861_/X sky130_fd_sc_hd__a21o_1
XANTENNA__3204__A0 _4964_/A0 VGND VGND VPWR VPWR sky130_fd_sc_hd__diode_2
X_2812_ _6087_/Q _2917_/A2 _2918_/B1 _6083_/Q VGND VGND VPWR VPWR _2812_/X sky130_fd_sc_hd__a22o_1
XTAP_TAPCELL_ROW_14_351 VGND VPWR sky130_fd_sc_hd__tapvpwrvgnd_1
X_5600_ _5697_/CLK _5600_/D fanout319/X VGND VGND VPWR VPWR _5600_/Q sky130_fd_sc_hd__dfrtp_1
X_3792_ _6167_/Q _3902_/A2 _3791_/X VGND VGND VPWR VPWR _3792_/X sky130_fd_sc_hd__o21a_1
XANTENNA__4952__A0 _2824_/C VGND VGND VPWR VPWR sky130_fd_sc_hd__diode_2
X_5531_ _6149_/CLK _5531_/D VGND VGND VPWR VPWR hold68/A sky130_fd_sc_hd__dfxtp_1
X_2743_ _4447_/A VGND VGND VPWR VPWR _4428_/A sky130_fd_sc_hd__inv_2
X_4413_ _4403_/A _4403_/B _4401_/A VGND VGND VPWR VPWR _4418_/A sky130_fd_sc_hd__a21o_1
XANTENNA__3507__B2 _6141_/D VGND VGND VPWR VPWR sky130_fd_sc_hd__diode_2
X_5393_ _6167_/Q _5442_/B VGND VGND VPWR VPWR _5402_/A sky130_fd_sc_hd__or2_1
X_4344_ _4344_/A _5247_/A _5210_/A _4344_/D VGND VGND VPWR VPWR _4344_/X sky130_fd_sc_hd__or4_1
Xfanout306 fanout309/X VGND VGND VPWR VPWR fanout306/X sky130_fd_sc_hd__buf_2
Xfanout339 fanout341/X VGND VGND VPWR VPWR fanout339/X sky130_fd_sc_hd__clkbuf_4
Xfanout328 fanout329/X VGND VGND VPWR VPWR fanout328/X sky130_fd_sc_hd__clkbuf_4
Xfanout317 fanout318/X VGND VGND VPWR VPWR fanout317/X sky130_fd_sc_hd__clkbuf_4
X_6014_ _6094_/CLK _6014_/D fanout350/X VGND VGND VPWR VPWR _6014_/Q sky130_fd_sc_hd__dfrtp_1
X_4275_ _5710_/Q _4266_/Y _4274_/Y _4266_/B VGND VGND VPWR VPWR _4275_/X sky130_fd_sc_hd__o22a_1
X_3226_ _4964_/A0 _5491_/Q _3229_/S VGND VGND VPWR VPWR _5491_/D sky130_fd_sc_hd__mux2_1
X_3157_ _5923_/Q _2978_/Y _3155_/X _3156_/X VGND VGND VPWR VPWR _3157_/X sky130_fd_sc_hd__o22a_1
XANTENNA__3140__C1 _3138_/B VGND VGND VPWR VPWR sky130_fd_sc_hd__diode_2
XTAP_TAPCELL_ROW_68_1035 VGND VPWR sky130_fd_sc_hd__tapvpwrvgnd_1
XTAP_TAPCELL_ROW_68_1024 VGND VPWR sky130_fd_sc_hd__tapvpwrvgnd_1
X_3088_ _4014_/A _3088_/B VGND VGND VPWR VPWR _5677_/D sky130_fd_sc_hd__nor2_1
XFILLER_42_418 VGND VGND VPWR VPWR sky130_fd_sc_hd__fill_2
XANTENNA__4640__C1 _4704_/C1 VGND VGND VPWR VPWR sky130_fd_sc_hd__diode_2
XANTENNA__4373__A _4829_/C VGND VGND VPWR VPWR sky130_fd_sc_hd__diode_2
XFILLER_52_27 VGND VGND VPWR VPWR sky130_fd_sc_hd__fill_1
XFILLER_22_131 VGND VGND VPWR VPWR sky130_fd_sc_hd__decap_4
XFILLER_23_665 VGND VGND VPWR VPWR sky130_fd_sc_hd__decap_6
XFILLER_23_676 VGND VGND VPWR VPWR sky130_fd_sc_hd__decap_6
XFILLER_10_304 VGND VGND VPWR VPWR sky130_fd_sc_hd__decap_4
XANTENNA__3563__A_N _3564_/B VGND VGND VPWR VPWR sky130_fd_sc_hd__diode_2
X_5729_ _5729_/CLK _5734_/Q fanout295/X VGND VGND VPWR VPWR _5729_/Q sky130_fd_sc_hd__dfrtp_1
XANTENNA__4943__A0 _5472_/Q VGND VGND VPWR VPWR sky130_fd_sc_hd__diode_2
XFILLER_10_348 VPWR VGND VPWR VGND sky130_ef_sc_hd__decap_12
XTAP_TAPCELL_ROW_79_1164 VGND VPWR sky130_fd_sc_hd__tapvpwrvgnd_1
Xhold371 _5710_/Q VGND VGND VPWR VPWR hold371/X sky130_fd_sc_hd__dlygate4sd3_1
Xhold360 _5953_/Q VGND VGND VPWR VPWR hold360/X sky130_fd_sc_hd__dlygate4sd3_1
XFILLER_2_525 VGND VGND VPWR VPWR sky130_fd_sc_hd__decap_6
Xhold382 _5924_/Q VGND VGND VPWR VPWR hold382/X sky130_fd_sc_hd__dlygate4sd3_1
Xhold393 _5961_/Q VGND VGND VPWR VPWR hold393/X sky130_fd_sc_hd__dlygate4sd3_1
XFILLER_77_315 VGND VGND VPWR VPWR sky130_fd_sc_hd__fill_1
XANTENNA__5143__S _5166_/S VGND VGND VPWR VPWR sky130_fd_sc_hd__diode_2
XFILLER_45_223 VGND VGND VPWR VPWR sky130_fd_sc_hd__fill_1
XFILLER_33_429 VGND VGND VPWR VPWR sky130_fd_sc_hd__fill_2
XFILLER_13_131 VGND VGND VPWR VPWR sky130_fd_sc_hd__fill_1
XFILLER_14_665 VGND VGND VPWR VPWR sky130_fd_sc_hd__fill_1
XFILLER_9_113 VPWR VGND VPWR VGND sky130_ef_sc_hd__decap_12
XANTENNA__4934__A0 _5469_/Q VGND VGND VPWR VPWR sky130_fd_sc_hd__diode_2
XTAP_TAPCELL_ROW_11_321 VGND VPWR sky130_fd_sc_hd__tapvpwrvgnd_1
XFILLER_9_146 VGND VGND VPWR VPWR sky130_fd_sc_hd__decap_4
XANTENNA__3627__A _4399_/A VGND VGND VPWR VPWR sky130_fd_sc_hd__diode_2
XANTENNA__6145__RESET_B fanout310/X VGND VGND VPWR VPWR sky130_fd_sc_hd__diode_2
X_4060_ hold83/A _3976_/B _3978_/A VGND VGND VPWR VPWR _4060_/X sky130_fd_sc_hd__a21o_1
X_3011_ hold81/A hold27/A hold40/A hold58/A _3954_/A _3955_/A VGND VGND VPWR VPWR
+ _3011_/X sky130_fd_sc_hd__mux4_1
XTAP_TAPCELL_ROW_19_421 VGND VPWR sky130_fd_sc_hd__tapvpwrvgnd_1
XTAP_TAPCELL_ROW_47_763 VGND VPWR sky130_fd_sc_hd__tapvpwrvgnd_1
X_4962_ _4719_/X _4971_/A2 _4971_/B1 _4961_/X VGND VGND VPWR VPWR _4962_/X sky130_fd_sc_hd__a22o_1
XANTENNA__4622__C1 _4686_/B1 VGND VGND VPWR VPWR sky130_fd_sc_hd__diode_2
XFILLER_36_289 VPWR VGND VPWR VGND sky130_ef_sc_hd__decap_12
X_4893_ _4214_/X _4971_/A2 _4971_/B1 _4892_/X VGND VGND VPWR VPWR _4893_/X sky130_fd_sc_hd__a22o_1
X_3913_ hold89/A _3913_/B VGND VGND VPWR VPWR _3913_/X sky130_fd_sc_hd__or2_1
X_3844_ _3384_/X _3767_/A _3840_/X _3783_/A VGND VGND VPWR VPWR _4116_/B sky130_fd_sc_hd__a22oi_2
XANTENNA__4925__A0 _5494_/Q VGND VGND VPWR VPWR sky130_fd_sc_hd__diode_2
XFILLER_32_495 VPWR VGND VPWR VGND sky130_ef_sc_hd__decap_12
X_3775_ _3916_/S _3774_/Y _3759_/S VGND VGND VPWR VPWR _3775_/Y sky130_fd_sc_hd__o21ai_1
X_2726_ _5494_/Q VGND VGND VPWR VPWR _2937_/A sky130_fd_sc_hd__inv_2
X_5514_ clkload4/A _5514_/D fanout278/X VGND VGND VPWR VPWR _5514_/Q sky130_fd_sc_hd__dfrtp_1
X_5445_ _5443_/X _5444_/Y _5441_/Y VGND VGND VPWR VPWR _6174_/D sky130_fd_sc_hd__o21ai_1
Xfanout103 _5025_/A2 VGND VGND VPWR VPWR _5027_/A2 sky130_fd_sc_hd__clkbuf_4
X_5376_ _5377_/A _5376_/B _5376_/C VGND VGND VPWR VPWR _5376_/X sky130_fd_sc_hd__and3_1
X_4327_ _4164_/A _4325_/A _4323_/Y _4266_/B VGND VGND VPWR VPWR _5722_/D sky130_fd_sc_hd__a211o_1
XFILLER_59_337 VGND VGND VPWR VPWR sky130_fd_sc_hd__fill_1
XANTENNA__4368__A _6109_/Q VGND VGND VPWR VPWR sky130_fd_sc_hd__diode_2
Xfanout114 _5235_/B VGND VGND VPWR VPWR _4344_/A sky130_fd_sc_hd__clkbuf_4
Xfanout136 _2955_/Y VGND VGND VPWR VPWR _3240_/B sky130_fd_sc_hd__clkbuf_4
XANTENNA__3272__A _5412_/A VGND VGND VPWR VPWR sky130_fd_sc_hd__diode_2
Xfanout147 _3905_/C VGND VGND VPWR VPWR _3893_/C sky130_fd_sc_hd__clkbuf_2
Xfanout125 _4877_/X VGND VGND VPWR VPWR _4878_/B sky130_fd_sc_hd__clkbuf_4
X_4258_ _4258_/A _4277_/S _4258_/C _4250_/Y VGND VGND VPWR VPWR _4312_/S sky130_fd_sc_hd__or4b_4
XFILLER_59_359 VGND VGND VPWR VPWR sky130_fd_sc_hd__fill_1
Xfanout158 _3978_/A VGND VGND VPWR VPWR _3976_/A sky130_fd_sc_hd__buf_2
X_3209_ _5645_/Q _3209_/B hold7/A VGND VGND VPWR VPWR _3958_/B sky130_fd_sc_hd__and3b_1
XFILLER_47_49 VGND VGND VPWR VPWR sky130_fd_sc_hd__fill_1
XFILLER_67_381 VGND VGND VPWR VPWR sky130_fd_sc_hd__decap_6
X_4189_ _4188_/X _4186_/X _4226_/S VGND VGND VPWR VPWR _4190_/B sky130_fd_sc_hd__mux2_1
XANTENNA__5199__A _5397_/A VGND VGND VPWR VPWR sky130_fd_sc_hd__diode_2
XFILLER_11_613 VGND VGND VPWR VPWR sky130_fd_sc_hd__decap_3
XANTENNA__4916__A0 _5491_/Q VGND VGND VPWR VPWR sky130_fd_sc_hd__diode_2
XFILLER_11_646 VGND VGND VPWR VPWR sky130_fd_sc_hd__decap_8
XFILLER_11_635 VGND VGND VPWR VPWR sky130_fd_sc_hd__decap_3
XFILLER_10_167 VPWR VGND VPWR VGND sky130_ef_sc_hd__decap_12
XANTENNA__3309__A_N _5412_/A VGND VGND VPWR VPWR sky130_fd_sc_hd__diode_2
XFILLER_2_300 VGND VGND VPWR VPWR sky130_fd_sc_hd__decap_8
Xhold190 _5508_/Q VGND VGND VPWR VPWR hold190/X sky130_fd_sc_hd__dlygate4sd3_1
XFILLER_77_167 VGND VGND VPWR VPWR sky130_fd_sc_hd__fill_1
XPHY_EDGE_ROW_16_Right_16 VGND VGND VPWR VPWR sky130_fd_sc_hd__decap_3
XFILLER_18_245 VGND VGND VPWR VPWR sky130_fd_sc_hd__fill_1
XANTENNA__3407__A0 _4973_/A0 VGND VGND VPWR VPWR sky130_fd_sc_hd__diode_2
XANTENNA__4217__S _4226_/S VGND VGND VPWR VPWR sky130_fd_sc_hd__diode_2
XTAP_TAPCELL_ROW_44_733 VGND VPWR sky130_fd_sc_hd__tapvpwrvgnd_1
XANTENNA__4907__A0 _5488_/Q VGND VGND VPWR VPWR sky130_fd_sc_hd__diode_2
XPHY_EDGE_ROW_25_Right_25 VGND VGND VPWR VPWR sky130_fd_sc_hd__decap_3
X_3560_ _3557_/Y _3558_/X _3555_/X _3556_/X VGND VGND VPWR VPWR _3560_/X sky130_fd_sc_hd__o211a_1
XANTENNA__2933__A2 _2930_/X VGND VGND VPWR VPWR sky130_fd_sc_hd__diode_2
X_3491_ _3491_/A _3491_/B _5207_/A VGND VGND VPWR VPWR _3491_/X sky130_fd_sc_hd__or3_1
X_5230_ _5230_/A _5230_/B _5211_/X VGND VGND VPWR VPWR _5230_/X sky130_fd_sc_hd__or3b_1
XFILLER_45_3 VPWR VGND VPWR VGND sky130_ef_sc_hd__decap_12
XFILLER_68_101 VGND VGND VPWR VPWR sky130_fd_sc_hd__decap_3
X_5161_ hold187/X _5471_/Q _5167_/S VGND VGND VPWR VPWR _6083_/D sky130_fd_sc_hd__mux2_1
X_5092_ hold241/X _2824_/C _5097_/S VGND VGND VPWR VPWR _6015_/D sky130_fd_sc_hd__mux2_1
X_4112_ _5568_/Q _4112_/B VGND VGND VPWR VPWR _4112_/Y sky130_fd_sc_hd__xnor2_1
X_4043_ hold88/X _3975_/Y _4041_/X _4042_/X VGND VGND VPWR VPWR _5661_/D sky130_fd_sc_hd__a22o_1
XANTENNA_hold10_A hold10/A VGND VGND VPWR VPWR sky130_fd_sc_hd__diode_2
XANTENNA__3820__A _5406_/A VGND VGND VPWR VPWR sky130_fd_sc_hd__diode_2
XPHY_EDGE_ROW_34_Right_34 VGND VGND VPWR VPWR sky130_fd_sc_hd__decap_3
XFILLER_25_705 VGND VGND VPWR VPWR sky130_fd_sc_hd__decap_8
XFILLER_64_384 VGND VGND VPWR VPWR sky130_fd_sc_hd__decap_6
X_5994_ _6115_/CLK _5994_/D fanout336/X VGND VGND VPWR VPWR _5994_/Q sky130_fd_sc_hd__dfrtp_1
X_4945_ hold382/X _4951_/A2 _4944_/X VGND VGND VPWR VPWR _5924_/D sky130_fd_sc_hd__a21o_1
XANTENNA__3949__A1 _3564_/A VGND VGND VPWR VPWR sky130_fd_sc_hd__diode_2
XTAP_TAPCELL_ROW_22_449 VGND VPWR sky130_fd_sc_hd__tapvpwrvgnd_1
X_4876_ _4876_/A _4978_/D VGND VGND VPWR VPWR _4876_/Y sky130_fd_sc_hd__nor2_1
X_3827_ _3887_/A _5854_/Q VGND VGND VPWR VPWR _3827_/X sky130_fd_sc_hd__and2_1
XPHY_EDGE_ROW_43_Right_43 VGND VGND VPWR VPWR sky130_fd_sc_hd__decap_3
X_3758_ _4112_/B _3757_/Y _3758_/S VGND VGND VPWR VPWR _3758_/X sky130_fd_sc_hd__mux2_1
XANTENNA__4797__S _4809_/S VGND VGND VPWR VPWR sky130_fd_sc_hd__diode_2
XTAP_TAPCELL_ROW_76_1134 VGND VPWR sky130_fd_sc_hd__tapvpwrvgnd_1
X_3689_ _4464_/A _6056_/Q _3717_/A _3712_/A VGND VGND VPWR VPWR _3693_/B sky130_fd_sc_hd__a211o_1
X_5428_ _5428_/A _5428_/B VGND VGND VPWR VPWR _5428_/X sky130_fd_sc_hd__and2_1
XFILLER_58_26 VGND VGND VPWR VPWR sky130_fd_sc_hd__fill_2
X_5359_ _5366_/A VGND VGND VPWR VPWR _5359_/Y sky130_fd_sc_hd__inv_2
XFILLER_59_156 VGND VGND VPWR VPWR sky130_fd_sc_hd__decap_6
XPHY_EDGE_ROW_52_Right_52 VGND VGND VPWR VPWR sky130_fd_sc_hd__decap_3
XFILLER_59_189 VGND VGND VPWR VPWR sky130_fd_sc_hd__decap_8
XANTENNA_fanout52_A _4678_/A1 VGND VGND VPWR VPWR sky130_fd_sc_hd__diode_2
XPHY_EDGE_ROW_61_Right_61 VGND VGND VPWR VPWR sky130_fd_sc_hd__decap_3
XFILLER_23_292 VGND VGND VPWR VPWR sky130_fd_sc_hd__fill_2
XFILLER_11_498 VGND VGND VPWR VPWR sky130_fd_sc_hd__decap_6
XANTENNA__2915__A2 _2910_/B VGND VGND VPWR VPWR sky130_fd_sc_hd__diode_2
XANTENNA__3905__A _3905_/A VGND VGND VPWR VPWR sky130_fd_sc_hd__diode_2
XPHY_EDGE_ROW_70_Right_70 VGND VGND VPWR VPWR sky130_fd_sc_hd__decap_3
XANTENNA__4668__A2 _4748_/A2 VGND VGND VPWR VPWR sky130_fd_sc_hd__diode_2
XFILLER_3_697 VPWR VGND VPWR VGND sky130_ef_sc_hd__decap_12
XFILLER_2_141 VGND VGND VPWR VPWR sky130_fd_sc_hd__fill_1
XANTENNA__3876__B1 _3725_/C VGND VGND VPWR VPWR sky130_fd_sc_hd__diode_2
XFILLER_66_616 VGND VGND VPWR VPWR sky130_fd_sc_hd__fill_1
XANTENNA__3640__A _4427_/A VGND VGND VPWR VPWR sky130_fd_sc_hd__diode_2
XFILLER_38_329 VGND VGND VPWR VPWR sky130_fd_sc_hd__fill_1
XFILLER_80_118 VGND VGND VPWR VPWR sky130_fd_sc_hd__decap_3
XTAP_TAPCELL_ROW_57_891 VGND VPWR sky130_fd_sc_hd__tapvpwrvgnd_1
XANTENNA__4174__C _5369_/A VGND VGND VPWR VPWR sky130_fd_sc_hd__diode_2
X_2991_ _5903_/Q _2987_/Y _2989_/Y VGND VGND VPWR VPWR _2991_/Y sky130_fd_sc_hd__o21ai_1
XFILLER_61_376 VGND VGND VPWR VPWR sky130_fd_sc_hd__decap_8
XANTENNA__5250__C1 _5353_/B VGND VGND VPWR VPWR sky130_fd_sc_hd__diode_2
X_4730_ _5798_/Q _4967_/A0 _4746_/S VGND VGND VPWR VPWR _4730_/X sky130_fd_sc_hd__mux2_1
XFILLER_9_53 VGND VGND VPWR VPWR sky130_fd_sc_hd__decap_3
XFILLER_14_281 VGND VGND VPWR VPWR sky130_fd_sc_hd__fill_1
X_4661_ _5956_/Q _5764_/Q _4679_/S VGND VGND VPWR VPWR _4661_/X sky130_fd_sc_hd__mux2_1
X_3612_ _4530_/A _6061_/Q _3691_/C _3713_/D VGND VGND VPWR VPWR _3617_/C sky130_fd_sc_hd__a211o_1
X_4592_ _4588_/X _4590_/X _4591_/X _4672_/A1 _4720_/C1 VGND VGND VPWR VPWR _4592_/X
+ sky130_fd_sc_hd__a221o_1
XANTENNA__2906__A2 _5523_/Q VGND VGND VPWR VPWR sky130_fd_sc_hd__diode_2
X_3543_ _3509_/Y _3546_/B _3525_/X _3549_/A VGND VGND VPWR VPWR _3543_/X sky130_fd_sc_hd__a31o_1
XANTENNA__6160__RESET_B fanout310/X VGND VGND VPWR VPWR sky130_fd_sc_hd__diode_2
X_3474_ _5217_/A _5230_/A VGND VGND VPWR VPWR _4344_/D sky130_fd_sc_hd__nand2_1
XANTENNA__4659__A2 _4747_/A2 VGND VGND VPWR VPWR sky130_fd_sc_hd__diode_2
X_5213_ _5195_/B _5226_/C _5212_/X VGND VGND VPWR VPWR _5213_/X sky130_fd_sc_hd__a21o_1
XFILLER_69_454 VGND VGND VPWR VPWR sky130_fd_sc_hd__decap_3
X_5144_ hold140/X _5520_/Q _5166_/S VGND VGND VPWR VPWR _6066_/D sky130_fd_sc_hd__mux2_1
XTAP_TAPCELL_ROW_71_1064 VGND VPWR sky130_fd_sc_hd__tapvpwrvgnd_1
XFILLER_28_29 VGND VGND VPWR VPWR sky130_fd_sc_hd__fill_1
X_5075_ hold294/X _5524_/Q _5098_/S VGND VGND VPWR VPWR _5998_/D sky130_fd_sc_hd__mux2_1
X_4026_ hold418/X _4022_/B _4025_/Y VGND VGND VPWR VPWR _5654_/D sky130_fd_sc_hd__o21a_1
XFILLER_71_129 VPWR VGND VPWR VGND sky130_ef_sc_hd__decap_12
XFILLER_71_118 VGND VGND VPWR VPWR sky130_fd_sc_hd__fill_2
XANTENNA__4831__A2 _3396_/A VGND VGND VPWR VPWR sky130_fd_sc_hd__diode_2
XTAP_TAPCELL_ROW_27_519 VGND VPWR sky130_fd_sc_hd__tapvpwrvgnd_1
XFILLER_25_535 VGND VGND VPWR VPWR sky130_fd_sc_hd__decap_3
X_5977_ clkload3/A _5977_/D fanout272/X VGND VGND VPWR VPWR _5977_/Q sky130_fd_sc_hd__dfrtp_1
X_4928_ _5467_/Q _4626_/X _4949_/S VGND VGND VPWR VPWR _4928_/X sky130_fd_sc_hd__mux2_1
XANTENNA_fanout142_X _5026_/A2 VGND VGND VPWR VPWR sky130_fd_sc_hd__diode_2
XFILLER_60_27 VGND VGND VPWR VPWR sky130_fd_sc_hd__fill_1
XFILLER_20_240 VGND VGND VPWR VPWR sky130_fd_sc_hd__decap_4
X_4859_ _5094_/A1 hold270/X _4863_/S VGND VGND VPWR VPWR _5893_/D sky130_fd_sc_hd__mux2_1
XANTENNA_clkbuf_leaf_7_clk_A clkbuf_leaf_9_clk/A VGND VGND VPWR VPWR sky130_fd_sc_hd__diode_2
XPHY_EDGE_ROW_8_Left_89 VGND VGND VPWR VPWR sky130_fd_sc_hd__decap_3
XTAP_TAPCELL_ROW_7_266 VGND VPWR sky130_fd_sc_hd__tapvpwrvgnd_1
XFILLER_0_645 VPWR VGND VPWR VGND sky130_ef_sc_hd__decap_12
XANTENNA__5151__S _5167_/S VGND VGND VPWR VPWR sky130_fd_sc_hd__diode_2
XANTENNA_fanout55_X _4678_/C1 VGND VGND VPWR VPWR sky130_fd_sc_hd__diode_2
XFILLER_28_340 VGND VGND VPWR VPWR sky130_fd_sc_hd__decap_4
XTAP_TAPCELL_ROW_54_861 VGND VPWR sky130_fd_sc_hd__tapvpwrvgnd_1
XTAP_TAPCELL_ROW_54_850 VGND VPWR sky130_fd_sc_hd__tapvpwrvgnd_1
XFILLER_31_505 VGND VGND VPWR VPWR sky130_fd_sc_hd__decap_8
XANTENNA__4586__A1 _5796_/Q VGND VGND VPWR VPWR sky130_fd_sc_hd__diode_2
XFILLER_43_387 VGND VGND VPWR VPWR sky130_fd_sc_hd__decap_3
XFILLER_8_701 VPWR VGND VPWR VGND sky130_ef_sc_hd__decap_12
XFILLER_50_60 VGND VGND VPWR VPWR sky130_fd_sc_hd__fill_1
X_3190_ _5864_/Q _5862_/Q VGND VGND VPWR VPWR _3752_/B sky130_fd_sc_hd__nor2_1
XANTENNA__5061__S _5066_/S VGND VGND VPWR VPWR sky130_fd_sc_hd__diode_2
XFILLER_38_137 VGND VGND VPWR VPWR sky130_fd_sc_hd__decap_3
XFILLER_39_638 VGND VGND VPWR VPWR sky130_fd_sc_hd__fill_1
XFILLER_39_649 VGND VGND VPWR VPWR sky130_fd_sc_hd__fill_1
X_5900_ _6032_/CLK _5900_/D fanout291/X VGND VGND VPWR VPWR _5900_/Q sky130_fd_sc_hd__dfrtp_4
XFILLER_53_107 VGND VGND VPWR VPWR sky130_fd_sc_hd__decap_4
XFILLER_34_321 VGND VGND VPWR VPWR sky130_fd_sc_hd__fill_1
X_5831_ _6091_/CLK _5831_/D fanout347/X VGND VGND VPWR VPWR _5831_/Q sky130_fd_sc_hd__dfrtp_1
XFILLER_34_365 VGND VGND VPWR VPWR sky130_fd_sc_hd__decap_8
X_2974_ _2977_/A _2980_/A _3129_/B _5960_/Q VGND VGND VPWR VPWR _2974_/X sky130_fd_sc_hd__and4_1
X_5762_ _6111_/CLK _5762_/D fanout327/X VGND VGND VPWR VPWR _5762_/Q sky130_fd_sc_hd__dfrtp_4
X_4713_ hold328/X _3880_/B _4712_/X VGND VGND VPWR VPWR _5787_/D sky130_fd_sc_hd__o21a_1
XTAP_TAPCELL_ROW_32_577 VGND VPWR sky130_fd_sc_hd__tapvpwrvgnd_1
X_5693_ _5696_/CLK _5693_/D VGND VGND VPWR VPWR hold63/A sky130_fd_sc_hd__dfxtp_1
X_4644_ _5954_/Q _4683_/A2 _4684_/A2 _5921_/Q _4643_/X VGND VGND VPWR VPWR _4644_/X
+ sky130_fd_sc_hd__a221o_1
XANTENNA__3001__B2 _2965_/X VGND VGND VPWR VPWR sky130_fd_sc_hd__diode_2
X_4575_ _5912_/Q _5761_/Q _4623_/S VGND VGND VPWR VPWR _4575_/X sky130_fd_sc_hd__mux2_1
XANTENNA_fanout102_A _5025_/A2 VGND VGND VPWR VPWR sky130_fd_sc_hd__diode_2
X_3526_ _3509_/Y _3546_/B _3525_/X _3508_/X VGND VGND VPWR VPWR _3526_/X sky130_fd_sc_hd__a31o_1
XANTENNA__3264__B _6129_/D VGND VGND VPWR VPWR sky130_fd_sc_hd__diode_2
X_3457_ _6133_/Q _6132_/Q _4350_/A _3470_/B VGND VGND VPWR VPWR _3458_/C sky130_fd_sc_hd__or4_1
XANTENNA__4501__A1 _3639_/A VGND VGND VPWR VPWR sky130_fd_sc_hd__diode_2
X_6176_ _6176_/CLK _6176_/D fanout286/X VGND VGND VPWR VPWR _6176_/Q sky130_fd_sc_hd__dfrtp_1
X_3388_ _5987_/Q _6031_/Q _3394_/S VGND VGND VPWR VPWR _3388_/X sky130_fd_sc_hd__mux2_1
XTAP_TAPCELL_ROW_4_236 VGND VPWR sky130_fd_sc_hd__tapvpwrvgnd_1
XTAP_TAPCELL_ROW_4_225 VGND VPWR sky130_fd_sc_hd__tapvpwrvgnd_1
X_5127_ hold91/X _5127_/B VGND VGND VPWR VPWR _6050_/D sky130_fd_sc_hd__or2_1
XPHY_EDGE_ROW_2_Right_2 VGND VGND VPWR VPWR sky130_fd_sc_hd__decap_3
X_5058_ _5982_/Q _5397_/A _5066_/S VGND VGND VPWR VPWR _5982_/D sky130_fd_sc_hd__mux2_1
X_4009_ _5646_/Q hold8/X VGND VGND VPWR VPWR _4009_/Y sky130_fd_sc_hd__nand2_1
XFILLER_44_107 VGND VGND VPWR VPWR sky130_fd_sc_hd__fill_1
XANTENNA__4568__A1 _4672_/A1 VGND VGND VPWR VPWR sky130_fd_sc_hd__diode_2
XFILLER_71_15 VGND VGND VPWR VPWR sky130_fd_sc_hd__decap_8
XTAP_TAPCELL_ROW_51_820 VGND VPWR sky130_fd_sc_hd__tapvpwrvgnd_1
XFILLER_4_203 VGND VGND VPWR VPWR sky130_fd_sc_hd__fill_1
XANTENNA__5146__S _5166_/S VGND VGND VPWR VPWR sky130_fd_sc_hd__diode_2
XANTENNA__4050__S _4052_/S VGND VGND VPWR VPWR sky130_fd_sc_hd__diode_2
XTAP_TAPCELL_ROW_59_920 VGND VPWR sky130_fd_sc_hd__tapvpwrvgnd_1
Xhold50 hold50/A VGND VGND VPWR VPWR hold50/X sky130_fd_sc_hd__dlygate4sd3_1
Xhold72 hold72/A VGND VGND VPWR VPWR hold72/X sky130_fd_sc_hd__dlygate4sd3_1
Xhold61 hold61/A VGND VGND VPWR VPWR hold61/X sky130_fd_sc_hd__dlygate4sd3_1
Xhold83 hold83/A VGND VGND VPWR VPWR hold83/X sky130_fd_sc_hd__dlygate4sd3_1
XFILLER_29_671 VGND VGND VPWR VPWR sky130_fd_sc_hd__fill_1
Xhold94 hold94/A VGND VGND VPWR VPWR hold94/X sky130_fd_sc_hd__dlygate4sd3_1
XFILLER_16_321 VGND VGND VPWR VPWR sky130_fd_sc_hd__fill_1
XFILLER_28_170 VGND VGND VPWR VPWR sky130_fd_sc_hd__fill_1
XFILLER_16_365 VGND VGND VPWR VPWR sky130_fd_sc_hd__fill_2
XANTENNA__4559__A1 _5767_/Q VGND VGND VPWR VPWR sky130_fd_sc_hd__diode_2
XFILLER_31_368 VGND VGND VPWR VPWR sky130_fd_sc_hd__decap_8
XANTENNA__4731__A1 _4747_/B1 VGND VGND VPWR VPWR sky130_fd_sc_hd__diode_2
X_4360_ _6109_/Q _5736_/Q _5737_/Q VGND VGND VPWR VPWR _4360_/Y sky130_fd_sc_hd__o21ai_1
XANTENNA__5056__S _5066_/S VGND VGND VPWR VPWR sky130_fd_sc_hd__diode_2
XFILLER_6_87 VGND VGND VPWR VPWR sky130_fd_sc_hd__fill_1
X_3311_ _6172_/Q _5986_/Q VGND VGND VPWR VPWR _3362_/C sky130_fd_sc_hd__and2b_1
X_4291_ _4218_/X _4290_/X _4291_/S VGND VGND VPWR VPWR _4291_/X sky130_fd_sc_hd__mux2_1
X_3242_ _6135_/Q _6134_/Q _6136_/Q VGND VGND VPWR VPWR _3470_/B sky130_fd_sc_hd__nand3b_1
X_6030_ _6050_/CLK _6030_/D fanout292/X VGND VGND VPWR VPWR _6030_/Q sky130_fd_sc_hd__dfrtp_1
X_3173_ hold92/X _5608_/Q VGND VGND VPWR VPWR hold93/A sky130_fd_sc_hd__nor2_1
XANTENNA__5039__A2 _5043_/A2 VGND VGND VPWR VPWR sky130_fd_sc_hd__diode_2
Xclkbuf_leaf_46_clk clkload1/A VGND VGND VPWR VPWR _6160_/CLK sky130_fd_sc_hd__clkbuf_8
XTAP_TAPCELL_ROW_37_647 VGND VPWR sky130_fd_sc_hd__tapvpwrvgnd_1
XTAP_TAPCELL_ROW_65_989 VGND VPWR sky130_fd_sc_hd__tapvpwrvgnd_1
XANTENNA__5458__C _5458_/C VGND VGND VPWR VPWR sky130_fd_sc_hd__diode_2
XFILLER_22_302 VGND VGND VPWR VPWR sky130_fd_sc_hd__fill_1
X_5814_ _6026_/CLK _5814_/D fanout279/X VGND VGND VPWR VPWR _5814_/Q sky130_fd_sc_hd__dfrtp_1
XTAP_TAPCELL_ROW_17_393 VGND VPWR sky130_fd_sc_hd__tapvpwrvgnd_1
XFILLER_34_195 VGND VGND VPWR VPWR sky130_fd_sc_hd__fill_1
XANTENNA__3222__A1 _5487_/Q VGND VGND VPWR VPWR sky130_fd_sc_hd__diode_2
X_2957_ _2734_/Y _3426_/D _2954_/X _6161_/Q VGND VGND VPWR VPWR _3114_/S sky130_fd_sc_hd__o211a_2
X_5745_ clkload6/A _5745_/D fanout284/X VGND VGND VPWR VPWR _5745_/Q sky130_fd_sc_hd__dfrtp_1
X_2888_ _5893_/Q _2917_/A2 _2918_/B1 _5889_/Q VGND VGND VPWR VPWR _2889_/C sky130_fd_sc_hd__a22o_1
X_5676_ _5697_/CLK _5676_/D fanout319/X VGND VGND VPWR VPWR _5676_/Q sky130_fd_sc_hd__dfrtp_4
X_4627_ _5919_/Q _4747_/A2 _4683_/B1 _4626_/X VGND VGND VPWR VPWR _4627_/X sky130_fd_sc_hd__a22o_1
XANTENNA__4722__A1 _4964_/A0 VGND VGND VPWR VPWR sky130_fd_sc_hd__diode_2
X_4558_ _5766_/Q _5174_/A2 _3564_/B _4551_/X VGND VGND VPWR VPWR _5766_/D sky130_fd_sc_hd__a22o_1
XFILLER_1_239 VPWR VGND VPWR VGND sky130_ef_sc_hd__decap_12
X_4489_ _4527_/S _4522_/D _4488_/Y _4486_/X VGND VGND VPWR VPWR _4489_/X sky130_fd_sc_hd__o31a_1
X_3509_ _3538_/A _3509_/B VGND VGND VPWR VPWR _3509_/Y sky130_fd_sc_hd__xnor2_2
XANTENNA__3289__A1 _5201_/B VGND VGND VPWR VPWR sky130_fd_sc_hd__diode_2
X_6159_ _6159_/CLK _6159_/D fanout283/X VGND VGND VPWR VPWR _6159_/Q sky130_fd_sc_hd__dfrtp_1
XANTENNA__3214__S _3219_/S VGND VGND VPWR VPWR sky130_fd_sc_hd__diode_2
XFILLER_72_213 VGND VGND VPWR VPWR sky130_fd_sc_hd__fill_1
XFILLER_26_641 VGND VGND VPWR VPWR sky130_fd_sc_hd__decap_3
Xclkbuf_leaf_37_clk clkload1/A VGND VGND VPWR VPWR _5697_/CLK sky130_fd_sc_hd__clkbuf_8
XFILLER_45_449 VGND VGND VPWR VPWR sky130_fd_sc_hd__fill_1
XFILLER_60_419 VGND VGND VPWR VPWR sky130_fd_sc_hd__fill_1
XFILLER_25_151 VGND VGND VPWR VPWR sky130_fd_sc_hd__decap_3
XFILLER_9_306 VGND VGND VPWR VPWR sky130_fd_sc_hd__fill_1
XFILLER_41_677 VGND VGND VPWR VPWR sky130_fd_sc_hd__fill_1
XFILLER_9_317 VGND VGND VPWR VPWR sky130_fd_sc_hd__decap_3
XFILLER_40_187 VGND VGND VPWR VPWR sky130_fd_sc_hd__decap_8
XANTENNA__3764__A2 _3725_/C VGND VGND VPWR VPWR sky130_fd_sc_hd__diode_2
XFILLER_5_501 VGND VGND VPWR VPWR sky130_fd_sc_hd__decap_3
Xclkbuf_leaf_28_clk clkload2/A VGND VGND VPWR VPWR _6091_/CLK sky130_fd_sc_hd__clkbuf_8
XFILLER_56_81 VGND VGND VPWR VPWR sky130_fd_sc_hd__decap_3
XTAP_TAPCELL_ROW_34_606 VGND VPWR sky130_fd_sc_hd__tapvpwrvgnd_1
XTAP_TAPCELL_ROW_62_959 VGND VPWR sky130_fd_sc_hd__tapvpwrvgnd_1
X_3860_ _5576_/Q _3860_/B VGND VGND VPWR VPWR _3860_/Y sky130_fd_sc_hd__nor2_1
XFILLER_31_143 VGND VGND VPWR VPWR sky130_fd_sc_hd__fill_1
X_2811_ _6071_/Q _2916_/B _2886_/B _6091_/Q _2810_/X VGND VGND VPWR VPWR _2811_/X
+ sky130_fd_sc_hd__a221o_1
XANTENNA_clkbuf_leaf_32_clk_A clkload2/A VGND VGND VPWR VPWR sky130_fd_sc_hd__diode_2
XTAP_TAPCELL_ROW_14_352 VGND VPWR sky130_fd_sc_hd__tapvpwrvgnd_1
X_3791_ _3651_/B _4762_/C _3790_/X _3905_/B VGND VGND VPWR VPWR _3791_/X sky130_fd_sc_hd__a211o_1
XFILLER_75_3 VPWR VGND VPWR VGND sky130_ef_sc_hd__decap_12
X_5530_ _6149_/CLK _5530_/D VGND VGND VPWR VPWR hold75/A sky130_fd_sc_hd__dfxtp_1
X_2742_ _4404_/A VGND VGND VPWR VPWR _4399_/A sky130_fd_sc_hd__inv_2
XFILLER_8_383 VGND VGND VPWR VPWR sky130_fd_sc_hd__fill_1
XANTENNA_clkbuf_leaf_47_clk_A clkload1/A VGND VGND VPWR VPWR sky130_fd_sc_hd__diode_2
X_4412_ _4424_/A _4475_/B VGND VGND VPWR VPWR _4412_/Y sky130_fd_sc_hd__nand2_1
X_5392_ _5387_/A _5387_/B _5385_/A VGND VGND VPWR VPWR _5395_/A sky130_fd_sc_hd__a21o_1
XANTENNA__4704__A1 _4226_/S VGND VGND VPWR VPWR sky130_fd_sc_hd__diode_2
X_4343_ _4344_/A _5197_/B VGND VGND VPWR VPWR _5353_/B sky130_fd_sc_hd__nor2_4
Xfanout307 fanout309/X VGND VGND VPWR VPWR fanout307/X sky130_fd_sc_hd__clkbuf_4
X_4274_ _4273_/B _4272_/X _4273_/Y VGND VGND VPWR VPWR _4274_/Y sky130_fd_sc_hd__o21ai_1
Xfanout329 fanout352/X VGND VGND VPWR VPWR fanout329/X sky130_fd_sc_hd__clkbuf_4
Xfanout318 fanout324/X VGND VGND VPWR VPWR fanout318/X sky130_fd_sc_hd__clkbuf_2
X_6013_ _6021_/CLK _6013_/D fanout333/X VGND VGND VPWR VPWR _6013_/Q sky130_fd_sc_hd__dfrtp_1
X_3225_ _2934_/B _5490_/Q _3229_/S VGND VGND VPWR VPWR _5490_/D sky130_fd_sc_hd__mux2_1
XANTENNA__4468__B1 _3623_/A VGND VGND VPWR VPWR sky130_fd_sc_hd__diode_2
XFILLER_39_232 VGND VGND VPWR VPWR sky130_fd_sc_hd__fill_1
X_3156_ _5940_/Q _2980_/Y _3153_/X _3154_/X VGND VGND VPWR VPWR _3156_/X sky130_fd_sc_hd__a22o_1
XTAP_TAPCELL_ROW_68_1036 VGND VPWR sky130_fd_sc_hd__tapvpwrvgnd_1
XTAP_TAPCELL_ROW_68_1025 VGND VPWR sky130_fd_sc_hd__tapvpwrvgnd_1
Xclkbuf_leaf_19_clk clkbuf_leaf_9_clk/A VGND VGND VPWR VPWR _5965_/CLK sky130_fd_sc_hd__clkbuf_8
X_3087_ _3087_/A _3087_/B VGND VGND VPWR VPWR _5669_/D sky130_fd_sc_hd__nor2_1
XFILLER_27_427 VGND VGND VPWR VPWR sky130_fd_sc_hd__decap_8
XANTENNA__4373__B _4475_/B VGND VGND VPWR VPWR sky130_fd_sc_hd__diode_2
XFILLER_50_441 VGND VGND VPWR VPWR sky130_fd_sc_hd__fill_1
X_5728_ _5966_/CLK _5728_/D fanout305/X VGND VGND VPWR VPWR _5728_/Q sky130_fd_sc_hd__dfrtp_4
X_3989_ _3989_/A VGND VGND VPWR VPWR _5623_/D sky130_fd_sc_hd__inv_2
XFILLER_6_309 VGND VGND VPWR VPWR sky130_fd_sc_hd__fill_1
XTAP_TAPCELL_ROW_79_1165 VGND VPWR sky130_fd_sc_hd__tapvpwrvgnd_1
X_5659_ _5690_/CLK _5659_/D VGND VGND VPWR VPWR _5659_/Q sky130_fd_sc_hd__dfxtp_1
XANTENNA__4171__A2 _4167_/Y VGND VGND VPWR VPWR sky130_fd_sc_hd__diode_2
Xhold361 _5975_/Q VGND VGND VPWR VPWR hold361/X sky130_fd_sc_hd__dlygate4sd3_1
Xhold350 _6123_/Q VGND VGND VPWR VPWR hold350/X sky130_fd_sc_hd__dlygate4sd3_1
Xhold383 _5923_/Q VGND VGND VPWR VPWR hold383/X sky130_fd_sc_hd__dlygate4sd3_1
Xhold372 _5957_/Q VGND VGND VPWR VPWR hold372/X sky130_fd_sc_hd__dlygate4sd3_1
Xhold394 _6147_/Q VGND VGND VPWR VPWR hold394/X sky130_fd_sc_hd__dlygate4sd3_1
XANTENNA__5120__A1 _3647_/A VGND VGND VPWR VPWR sky130_fd_sc_hd__diode_2
XANTENNA__3682__A1 _4464_/A VGND VGND VPWR VPWR sky130_fd_sc_hd__diode_2
XFILLER_73_566 VGND VGND VPWR VPWR sky130_fd_sc_hd__fill_1
XFILLER_45_268 VGND VGND VPWR VPWR sky130_fd_sc_hd__fill_2
XFILLER_9_125 VGND VGND VPWR VPWR sky130_fd_sc_hd__decap_8
XFILLER_41_474 VGND VGND VPWR VPWR sky130_fd_sc_hd__fill_1
XANTENNA__3198__A0 _5094_/A1 VGND VGND VPWR VPWR sky130_fd_sc_hd__diode_2
XTAP_TAPCELL_ROW_11_322 VGND VPWR sky130_fd_sc_hd__tapvpwrvgnd_1
XFILLER_13_187 VGND VGND VPWR VPWR sky130_fd_sc_hd__decap_4
XFILLER_42_83 VGND VGND VPWR VPWR sky130_fd_sc_hd__fill_1
XPHY_EDGE_ROW_39_Left_120 VGND VGND VPWR VPWR sky130_fd_sc_hd__decap_3
XFILLER_3_55 VGND VGND VPWR VPWR sky130_fd_sc_hd__fill_1
XANTENNA__4177__C _4177_/C VGND VGND VPWR VPWR sky130_fd_sc_hd__diode_2
XANTENNA__5111__A1 _3905_/A VGND VGND VPWR VPWR sky130_fd_sc_hd__diode_2
XFILLER_67_80 VGND VGND VPWR VPWR sky130_fd_sc_hd__fill_1
XFILLER_3_99 VGND VGND VPWR VPWR sky130_fd_sc_hd__decap_4
X_3010_ _5676_/Q _5595_/Q _2958_/X _5604_/Q VGND VGND VPWR VPWR _3010_/X sky130_fd_sc_hd__a22o_1
XTAP_TAPCELL_ROW_19_422 VGND VPWR sky130_fd_sc_hd__tapvpwrvgnd_1
XANTENNA__4870__B1 _4167_/Y VGND VGND VPWR VPWR sky130_fd_sc_hd__diode_2
XTAP_TAPCELL_ROW_47_764 VGND VPWR sky130_fd_sc_hd__tapvpwrvgnd_1
X_4961_ _2934_/B _4714_/X _4973_/S VGND VGND VPWR VPWR _4961_/X sky130_fd_sc_hd__mux2_1
XFILLER_24_419 VGND VGND VPWR VPWR sky130_fd_sc_hd__fill_1
X_4892_ _5797_/Q _5521_/Q _4901_/S VGND VGND VPWR VPWR _4892_/X sky130_fd_sc_hd__mux2_1
X_3912_ _5581_/Q _3912_/B VGND VGND VPWR VPWR _3912_/Y sky130_fd_sc_hd__xnor2_1
XANTENNA__5178__A1 _4427_/A VGND VGND VPWR VPWR sky130_fd_sc_hd__diode_2
X_3843_ _5809_/Q _3904_/S _3842_/X _3906_/A1 VGND VGND VPWR VPWR _3843_/X sky130_fd_sc_hd__o211a_1
X_3774_ _5569_/Q _3785_/C VGND VGND VPWR VPWR _3774_/Y sky130_fd_sc_hd__xnor2_1
X_2725_ _5489_/Q VGND VGND VPWR VPWR _2725_/Y sky130_fd_sc_hd__inv_2
XFILLER_8_180 VPWR VGND VPWR VGND sky130_ef_sc_hd__decap_12
X_5513_ _6050_/CLK _5513_/D fanout290/X VGND VGND VPWR VPWR _5513_/Q sky130_fd_sc_hd__dfrtp_1
X_5444_ _5434_/X _5437_/Y _5442_/Y _5410_/C VGND VGND VPWR VPWR _5444_/Y sky130_fd_sc_hd__o31ai_1
Xclkbuf_leaf_8_clk clkbuf_leaf_9_clk/A VGND VGND VPWR VPWR _6050_/CLK sky130_fd_sc_hd__clkbuf_8
Xfanout104 _4979_/Y VGND VGND VPWR VPWR _5025_/A2 sky130_fd_sc_hd__buf_2
X_5375_ _5377_/A _5453_/B VGND VGND VPWR VPWR _5378_/A sky130_fd_sc_hd__and2_1
X_4326_ _5721_/Q _4157_/A _4246_/S _4325_/X _4323_/Y VGND VGND VPWR VPWR _5721_/D
+ sky130_fd_sc_hd__a221o_1
Xfanout126 _4877_/X VGND VGND VPWR VPWR _4971_/B1 sky130_fd_sc_hd__buf_2
XFILLER_59_327 VGND VGND VPWR VPWR sky130_fd_sc_hd__fill_1
XANTENNA__4368__B _5736_/Q VGND VGND VPWR VPWR sky130_fd_sc_hd__diode_2
Xfanout115 _3240_/X VGND VGND VPWR VPWR _5235_/B sky130_fd_sc_hd__clkbuf_2
X_4257_ _2776_/A _4155_/A _4253_/Y _4254_/Y _4266_/B VGND VGND VPWR VPWR _4258_/C
+ sky130_fd_sc_hd__a311o_1
Xfanout159 _4674_/S VGND VGND VPWR VPWR _4682_/S sky130_fd_sc_hd__clkbuf_4
XANTENNA__5102__A1 _6167_/Q VGND VGND VPWR VPWR sky130_fd_sc_hd__diode_2
Xfanout148 _3879_/S VGND VGND VPWR VPWR _3904_/S sky130_fd_sc_hd__clkbuf_4
X_4188_ _4187_/X _4183_/X _4234_/S VGND VGND VPWR VPWR _4188_/X sky130_fd_sc_hd__mux2_1
X_3208_ _3208_/A _3956_/S _3208_/C _5611_/Q VGND VGND VPWR VPWR _3209_/B sky130_fd_sc_hd__or4b_1
XANTENNA__4861__A0 _4964_/A0 VGND VGND VPWR VPWR sky130_fd_sc_hd__diode_2
XFILLER_55_533 VGND VGND VPWR VPWR sky130_fd_sc_hd__fill_1
X_3139_ _4943_/S _4561_/A _5189_/A2 _3137_/Y _2993_/D VGND VGND VPWR VPWR _3139_/X
+ sky130_fd_sc_hd__o41a_1
XANTENNA_fanout172_X _2964_/B VGND VGND VPWR VPWR sky130_fd_sc_hd__diode_2
XFILLER_15_408 VPWR VGND VPWR VGND sky130_ef_sc_hd__decap_12
XANTENNA__5199__B _5406_/A VGND VGND VPWR VPWR sky130_fd_sc_hd__diode_2
XFILLER_42_238 VPWR VGND VPWR VGND sky130_ef_sc_hd__decap_12
XANTENNA__5169__A1 _5475_/Q VGND VGND VPWR VPWR sky130_fd_sc_hd__diode_2
XFILLER_11_625 VGND VGND VPWR VPWR sky130_fd_sc_hd__fill_2
XANTENNA__2927__B1 _2927_/B1 VGND VGND VPWR VPWR sky130_fd_sc_hd__diode_2
XFILLER_6_106 VGND VGND VPWR VPWR sky130_fd_sc_hd__decap_6
XFILLER_10_179 VGND VGND VPWR VPWR sky130_fd_sc_hd__decap_6
Xhold180 _5703_/Q VGND VGND VPWR VPWR hold180/X sky130_fd_sc_hd__dlygate4sd3_1
XANTENNA__5154__S _5166_/S VGND VGND VPWR VPWR sky130_fd_sc_hd__diode_2
XFILLER_5_3 VGND VGND VPWR VPWR sky130_fd_sc_hd__fill_2
XANTENNA__3463__A _6128_/D VGND VGND VPWR VPWR sky130_fd_sc_hd__diode_2
Xhold191 _5733_/Q VGND VGND VPWR VPWR hold191/X sky130_fd_sc_hd__dlygate4sd3_1
XFILLER_77_113 VPWR VGND VPWR VGND sky130_ef_sc_hd__decap_12
XANTENNA__4852__A0 _5470_/Q VGND VGND VPWR VPWR sky130_fd_sc_hd__diode_2
XFILLER_58_371 VGND VGND VPWR VPWR sky130_fd_sc_hd__decap_4
XANTENNA__3402__S _3407_/S VGND VGND VPWR VPWR sky130_fd_sc_hd__diode_2
XANTENNA__3407__A1 _5524_/Q VGND VGND VPWR VPWR sky130_fd_sc_hd__diode_2
XANTENNA__4604__B1 _4684_/B1 VGND VGND VPWR VPWR sky130_fd_sc_hd__diode_2
XFILLER_61_547 VGND VGND VPWR VPWR sky130_fd_sc_hd__fill_1
XTAP_TAPCELL_ROW_44_734 VGND VPWR sky130_fd_sc_hd__tapvpwrvgnd_1
XTAP_TAPCELL_ROW_24_480 VGND VPWR sky130_fd_sc_hd__tapvpwrvgnd_1
XFILLER_41_293 VGND VGND VPWR VPWR sky130_fd_sc_hd__fill_1
XANTENNA__2918__B1 _2918_/B1 VGND VGND VPWR VPWR sky130_fd_sc_hd__diode_2
X_3490_ _3530_/A _3567_/B VGND VGND VPWR VPWR _5207_/A sky130_fd_sc_hd__nor2_1
XANTENNA__5064__S _5066_/S VGND VGND VPWR VPWR sky130_fd_sc_hd__diode_2
X_5160_ hold213/X _5470_/Q _5172_/S VGND VGND VPWR VPWR _6082_/D sky130_fd_sc_hd__mux2_1
XFILLER_38_3 VGND VGND VPWR VPWR sky130_fd_sc_hd__decap_3
XANTENNA__3894__A1 _3783_/A VGND VGND VPWR VPWR sky130_fd_sc_hd__diode_2
X_5091_ hold252/X _5474_/Q _5099_/S VGND VGND VPWR VPWR _6014_/D sky130_fd_sc_hd__mux2_1
X_4111_ _4109_/Y _4110_/X _3758_/S VGND VGND VPWR VPWR _4115_/A sky130_fd_sc_hd__a21o_1
X_4042_ hold82/A _4541_/S _3976_/A VGND VGND VPWR VPWR _4042_/X sky130_fd_sc_hd__a21o_1
XANTENNA__4843__A0 _5489_/Q VGND VGND VPWR VPWR sky130_fd_sc_hd__diode_2
XFILLER_64_374 VGND VGND VPWR VPWR sky130_fd_sc_hd__decap_8
XFILLER_64_363 VGND VGND VPWR VPWR sky130_fd_sc_hd__fill_1
X_5993_ _6115_/CLK _5993_/D fanout341/X VGND VGND VPWR VPWR _5993_/Q sky130_fd_sc_hd__dfrtp_1
XFILLER_24_227 VGND VGND VPWR VPWR sky130_fd_sc_hd__fill_1
X_4944_ _4671_/X _4878_/A _4878_/B _4943_/X VGND VGND VPWR VPWR _4944_/X sky130_fd_sc_hd__a22o_1
XFILLER_32_271 VPWR VGND VPWR VGND sky130_ef_sc_hd__decap_12
X_4875_ _5863_/Q _5935_/Q VGND VGND VPWR VPWR _4978_/D sky130_fd_sc_hd__nand2_1
X_3826_ _5573_/Q _3825_/X _3826_/S VGND VGND VPWR VPWR _5573_/D sky130_fd_sc_hd__mux2_1
X_3757_ _3785_/C _3757_/B VGND VGND VPWR VPWR _3757_/Y sky130_fd_sc_hd__nor2_1
XTAP_TAPCELL_ROW_76_1124 VGND VPWR sky130_fd_sc_hd__tapvpwrvgnd_1
XTAP_TAPCELL_ROW_76_1135 VGND VPWR sky130_fd_sc_hd__tapvpwrvgnd_1
X_3688_ _5750_/Q _6061_/Q VGND VGND VPWR VPWR _3688_/Y sky130_fd_sc_hd__xnor2_1
XANTENNA__3554__Y _3554_/Y VGND VGND VPWR VPWR sky130_fd_sc_hd__diode_2
XANTENNA__4379__A _4829_/C VGND VGND VPWR VPWR sky130_fd_sc_hd__diode_2
XANTENNA__3283__A _6167_/Q VGND VGND VPWR VPWR sky130_fd_sc_hd__diode_2
X_5427_ _5427_/A _5427_/B VGND VGND VPWR VPWR _5428_/B sky130_fd_sc_hd__or2_1
X_5358_ _5358_/A _5447_/B VGND VGND VPWR VPWR _5366_/A sky130_fd_sc_hd__or2_2
X_4309_ _4245_/X _4308_/X _5458_/C VGND VGND VPWR VPWR _4309_/X sky130_fd_sc_hd__mux2_1
XFILLER_59_113 VGND VGND VPWR VPWR sky130_fd_sc_hd__decap_6
X_5289_ _5289_/A _5289_/B VGND VGND VPWR VPWR _5289_/Y sky130_fd_sc_hd__xnor2_1
XFILLER_74_15 VGND VGND VPWR VPWR sky130_fd_sc_hd__decap_8
XFILLER_28_522 VGND VGND VPWR VPWR sky130_fd_sc_hd__fill_1
XFILLER_28_533 VGND VGND VPWR VPWR sky130_fd_sc_hd__fill_2
XFILLER_74_149 VGND VGND VPWR VPWR sky130_fd_sc_hd__fill_2
XFILLER_74_37 VPWR VGND VPWR VGND sky130_ef_sc_hd__decap_12
XANTENNA__3222__S _3229_/S VGND VGND VPWR VPWR sky130_fd_sc_hd__diode_2
XANTENNA_fanout45_A _4740_/B1 VGND VGND VPWR VPWR sky130_fd_sc_hd__diode_2
XANTENNA__5149__S _5172_/S VGND VGND VPWR VPWR sky130_fd_sc_hd__diode_2
XANTENNA__3905__B _3905_/B VGND VGND VPWR VPWR sky130_fd_sc_hd__diode_2
XANTENNA__4576__X _4576_/X VGND VGND VPWR VPWR sky130_fd_sc_hd__diode_2
XANTENNA__3628__A1 _4399_/A VGND VGND VPWR VPWR sky130_fd_sc_hd__diode_2
XANTENNA__3628__B2 _4452_/A VGND VGND VPWR VPWR sky130_fd_sc_hd__diode_2
XFILLER_19_522 VGND VGND VPWR VPWR sky130_fd_sc_hd__decap_4
XFILLER_46_385 VGND VGND VPWR VPWR sky130_fd_sc_hd__fill_1
XTAP_TAPCELL_ROW_57_892 VGND VPWR sky130_fd_sc_hd__tapvpwrvgnd_1
XANTENNA__4174__D _4175_/D VGND VGND VPWR VPWR sky130_fd_sc_hd__diode_2
X_2990_ _4175_/A _5935_/Q VGND VGND VPWR VPWR _2993_/D sky130_fd_sc_hd__or2_1
XANTENNA__5059__S _5123_/B VGND VGND VPWR VPWR sky130_fd_sc_hd__diode_2
X_4660_ _5956_/Q _4748_/A2 _4740_/B1 _4659_/X VGND VGND VPWR VPWR _4660_/X sky130_fd_sc_hd__a211o_1
XANTENNA__5002__B1 _5024_/B1 VGND VGND VPWR VPWR sky130_fd_sc_hd__diode_2
X_3611_ _3656_/A _6057_/Q VGND VGND VPWR VPWR _3713_/D sky130_fd_sc_hd__nor2_1
XFILLER_9_98 VPWR VGND VPWR VGND sky130_ef_sc_hd__decap_12
X_4591_ _5914_/Q _5763_/Q _4615_/S VGND VGND VPWR VPWR _4591_/X sky130_fd_sc_hd__mux2_1
X_3542_ _3546_/B _3525_/X _3509_/Y VGND VGND VPWR VPWR _3542_/Y sky130_fd_sc_hd__a21oi_1
X_3473_ _5217_/A _5230_/A VGND VGND VPWR VPWR _5237_/A sky130_fd_sc_hd__and2_1
X_5212_ _3452_/X _5206_/Y _5211_/X _3480_/X VGND VGND VPWR VPWR _5212_/X sky130_fd_sc_hd__a31o_1
XFILLER_69_422 VGND VGND VPWR VPWR sky130_fd_sc_hd__fill_1
X_5143_ hold128/X _5519_/Q _5166_/S VGND VGND VPWR VPWR _6065_/D sky130_fd_sc_hd__mux2_1
XANTENNA__3867__B2 _3783_/A VGND VGND VPWR VPWR sky130_fd_sc_hd__diode_2
XTAP_TAPCELL_ROW_71_1065 VGND VPWR sky130_fd_sc_hd__tapvpwrvgnd_1
X_5074_ hold204/X _5523_/Q _5098_/S VGND VGND VPWR VPWR _5997_/D sky130_fd_sc_hd__mux2_1
XFILLER_56_105 VGND VGND VPWR VPWR sky130_fd_sc_hd__fill_1
X_4025_ hold11/A _4027_/B VGND VGND VPWR VPWR _4025_/Y sky130_fd_sc_hd__nor2_1
XFILLER_52_300 VGND VGND VPWR VPWR sky130_fd_sc_hd__fill_1
XFILLER_25_503 VGND VGND VPWR VPWR sky130_fd_sc_hd__fill_1
XFILLER_37_352 VGND VGND VPWR VPWR sky130_fd_sc_hd__fill_1
XFILLER_37_385 VGND VGND VPWR VPWR sky130_fd_sc_hd__decap_4
XFILLER_52_344 VGND VGND VPWR VPWR sky130_fd_sc_hd__fill_1
XFILLER_80_664 VGND VGND VPWR VPWR sky130_fd_sc_hd__fill_1
XANTENNA_fanout347_A fanout351/X VGND VGND VPWR VPWR sky130_fd_sc_hd__diode_2
X_5976_ clkload3/A _5976_/D fanout276/X VGND VGND VPWR VPWR _5976_/Q sky130_fd_sc_hd__dfrtp_1
XANTENNA__3549__Y _3549_/Y VGND VGND VPWR VPWR sky130_fd_sc_hd__diode_2
XANTENNA__4595__A2 _4684_/A2 VGND VGND VPWR VPWR sky130_fd_sc_hd__diode_2
X_4927_ hold446/X _4951_/A2 _4926_/X VGND VGND VPWR VPWR _5918_/D sky130_fd_sc_hd__a21o_1
X_4858_ _2843_/B hold288/X _4862_/S VGND VGND VPWR VPWR _5892_/D sky130_fd_sc_hd__mux2_1
X_3809_ _3906_/A1 _3906_/A2 _3807_/X _3808_/X VGND VGND VPWR VPWR _3810_/B sky130_fd_sc_hd__a31oi_1
X_4789_ _5489_/Q hold300/X _4805_/S VGND VGND VPWR VPWR _5826_/D sky130_fd_sc_hd__mux2_1
XANTENNA__4752__C1 _3877_/S VGND VGND VPWR VPWR sky130_fd_sc_hd__diode_2
XANTENNA__3217__S _3219_/S VGND VGND VPWR VPWR sky130_fd_sc_hd__diode_2
XANTENNA__3858__A1 _3783_/A VGND VGND VPWR VPWR sky130_fd_sc_hd__diode_2
XANTENNA__2909__X _6130_/D VGND VGND VPWR VPWR sky130_fd_sc_hd__diode_2
XTAP_TAPCELL_ROW_7_267 VGND VPWR sky130_fd_sc_hd__tapvpwrvgnd_1
XFILLER_0_657 VPWR VGND VPWR VGND sky130_ef_sc_hd__decap_12
XANTENNA__4807__A0 _4964_/A0 VGND VGND VPWR VPWR sky130_fd_sc_hd__diode_2
XFILLER_47_127 VGND VGND VPWR VPWR sky130_fd_sc_hd__fill_1
XFILLER_16_514 VGND VGND VPWR VPWR sky130_fd_sc_hd__decap_3
XFILLER_55_171 VPWR VGND VPWR VGND sky130_ef_sc_hd__decap_12
XANTENNA_fanout48_X _4704_/C1 VGND VGND VPWR VPWR sky130_fd_sc_hd__diode_2
XFILLER_16_536 VPWR VGND VPWR VGND sky130_ef_sc_hd__decap_12
XFILLER_43_333 VGND VGND VPWR VPWR sky130_fd_sc_hd__fill_1
XFILLER_43_344 VGND VGND VPWR VPWR sky130_fd_sc_hd__fill_1
XFILLER_70_141 VGND VGND VPWR VPWR sky130_fd_sc_hd__decap_8
XTAP_TAPCELL_ROW_54_851 VGND VPWR sky130_fd_sc_hd__tapvpwrvgnd_1
XFILLER_43_399 VGND VGND VPWR VPWR sky130_fd_sc_hd__fill_1
XFILLER_7_223 VGND VGND VPWR VPWR sky130_fd_sc_hd__fill_1
XFILLER_7_201 VGND VGND VPWR VPWR sky130_fd_sc_hd__decap_3
XFILLER_50_94 VPWR VGND VPWR VGND sky130_ef_sc_hd__decap_12
XANTENNA__3370__B _3877_/S VGND VGND VPWR VPWR sky130_fd_sc_hd__diode_2
XFILLER_75_80 VGND VGND VPWR VPWR sky130_fd_sc_hd__decap_8
XFILLER_62_620 VGND VGND VPWR VPWR sky130_fd_sc_hd__fill_1
X_5830_ _6021_/CLK _5830_/D fanout344/X VGND VGND VPWR VPWR _5830_/Q sky130_fd_sc_hd__dfrtp_1
XFILLER_61_141 VGND VGND VPWR VPWR sky130_fd_sc_hd__decap_6
X_2973_ _2977_/A _2980_/A _3129_/B VGND VGND VPWR VPWR _2973_/X sky130_fd_sc_hd__and3_1
X_5761_ _6111_/CLK _5761_/D fanout327/X VGND VGND VPWR VPWR _5761_/Q sky130_fd_sc_hd__dfrtp_4
X_4712_ _4708_/X _4710_/X _4711_/X _4226_/S _3877_/S VGND VGND VPWR VPWR _4712_/X
+ sky130_fd_sc_hd__a221o_1
XFILLER_30_550 VGND VGND VPWR VPWR sky130_fd_sc_hd__fill_1
XTAP_TAPCELL_ROW_32_578 VGND VPWR sky130_fd_sc_hd__tapvpwrvgnd_1
X_5692_ _6120_/CLK _5692_/D VGND VGND VPWR VPWR hold95/A sky130_fd_sc_hd__dfxtp_1
X_4643_ _4667_/B1 _4642_/X _4684_/B1 VGND VGND VPWR VPWR _4643_/X sky130_fd_sc_hd__a21o_1
XANTENNA__4734__C1 _4750_/C1 VGND VGND VPWR VPWR sky130_fd_sc_hd__diode_2
X_4574_ _4686_/A1 _4573_/X _4572_/X _4678_/C1 VGND VGND VPWR VPWR _4574_/X sky130_fd_sc_hd__o211a_1
X_3525_ _3522_/X _3523_/Y _3511_/Y _3515_/Y VGND VGND VPWR VPWR _3525_/X sky130_fd_sc_hd__a211o_1
X_3456_ _5197_/A _3918_/B VGND VGND VPWR VPWR _3495_/B sky130_fd_sc_hd__nand2_1
XANTENNA_fanout297_A fanout298/X VGND VGND VPWR VPWR sky130_fd_sc_hd__diode_2
X_6175_ _6176_/CLK _6175_/D fanout314/X VGND VGND VPWR VPWR _6175_/Q sky130_fd_sc_hd__dfrtp_1
X_3387_ hold167/X _3397_/A2 _4544_/A _3386_/X VGND VGND VPWR VPWR _5511_/D sky130_fd_sc_hd__a22o_1
XFILLER_69_296 VGND VGND VPWR VPWR sky130_fd_sc_hd__decap_3
XFILLER_69_263 VGND VGND VPWR VPWR sky130_fd_sc_hd__decap_6
XTAP_TAPCELL_ROW_4_226 VGND VPWR sky130_fd_sc_hd__tapvpwrvgnd_1
X_5126_ _4166_/B _5189_/A2 _5863_/D _5369_/A VGND VGND VPWR VPWR _6049_/D sky130_fd_sc_hd__a22o_1
XFILLER_57_447 VGND VGND VPWR VPWR sky130_fd_sc_hd__fill_1
X_5057_ _5981_/Q _6167_/Q _5066_/S VGND VGND VPWR VPWR _5981_/D sky130_fd_sc_hd__mux2_1
X_4008_ _5646_/Q hold8/A hold9/A VGND VGND VPWR VPWR _4008_/X sky130_fd_sc_hd__o21ba_1
XANTENNA__3271__A_N _5397_/A VGND VGND VPWR VPWR sky130_fd_sc_hd__diode_2
XANTENNA_fanout252_X _4408_/A VGND VGND VPWR VPWR sky130_fd_sc_hd__diode_2
XFILLER_25_366 VGND VGND VPWR VPWR sky130_fd_sc_hd__fill_1
X_5959_ _5967_/CLK _5959_/D fanout307/X VGND VGND VPWR VPWR _5959_/Q sky130_fd_sc_hd__dfrtp_1
XTAP_TAPCELL_ROW_51_821 VGND VPWR sky130_fd_sc_hd__tapvpwrvgnd_1
XFILLER_40_358 VGND VGND VPWR VPWR sky130_fd_sc_hd__decap_6
XFILLER_5_705 VGND VGND VPWR VPWR sky130_fd_sc_hd__decap_8
XANTENNA__4740__A2 _4740_/A2 VGND VGND VPWR VPWR sky130_fd_sc_hd__diode_2
XFILLER_4_237 VGND VGND VPWR VPWR sky130_fd_sc_hd__decap_3
XFILLER_4_259 VGND VGND VPWR VPWR sky130_fd_sc_hd__fill_1
XFILLER_0_421 VPWR VGND VPWR VGND sky130_ef_sc_hd__decap_12
XANTENNA__5162__S _5166_/S VGND VGND VPWR VPWR sky130_fd_sc_hd__diode_2
XFILLER_76_712 VGND VGND VPWR VPWR sky130_fd_sc_hd__fill_1
XTAP_TAPCELL_ROW_59_921 VGND VPWR sky130_fd_sc_hd__tapvpwrvgnd_1
Xhold40 hold40/A VGND VGND VPWR VPWR hold40/X sky130_fd_sc_hd__dlygate4sd3_1
XFILLER_29_51 VGND VGND VPWR VPWR sky130_fd_sc_hd__decap_4
Xhold73 hold73/A VGND VGND VPWR VPWR hold73/X sky130_fd_sc_hd__dlygate4sd3_1
Xhold62 hold62/A VGND VGND VPWR VPWR hold62/X sky130_fd_sc_hd__dlygate4sd3_1
Xhold51 hold51/A VGND VGND VPWR VPWR hold51/X sky130_fd_sc_hd__dlygate4sd3_1
Xhold95 hold95/A VGND VGND VPWR VPWR hold95/X sky130_fd_sc_hd__dlygate4sd3_1
Xhold84 hold84/A VGND VGND VPWR VPWR hold84/X sky130_fd_sc_hd__dlygate4sd3_1
XANTENNA__2806__A2 _2917_/A2 VGND VGND VPWR VPWR sky130_fd_sc_hd__diode_2
XFILLER_16_311 VGND VGND VPWR VPWR sky130_fd_sc_hd__fill_1
XFILLER_45_83 VGND VGND VPWR VPWR sky130_fd_sc_hd__decap_3
XFILLER_12_550 VGND VGND VPWR VPWR sky130_fd_sc_hd__fill_1
XFILLER_77_7 VGND VGND VPWR VPWR sky130_fd_sc_hd__fill_1
XPHY_EDGE_ROW_20_Left_101 VGND VGND VPWR VPWR sky130_fd_sc_hd__decap_3
X_3310_ _5984_/Q _5412_/A VGND VGND VPWR VPWR _3365_/C sky130_fd_sc_hd__and2b_1
X_4290_ _5710_/Q _4308_/A2 _4250_/Y _4289_/X VGND VGND VPWR VPWR _4290_/X sky130_fd_sc_hd__a22o_1
XFILLER_3_281 VPWR VGND VPWR VGND sky130_ef_sc_hd__decap_12
X_3241_ _6125_/Q _6126_/Q _6127_/Q _5217_/A VGND VGND VPWR VPWR _4350_/A sky130_fd_sc_hd__or4b_4
X_3172_ hold16/X hold6/X VGND VGND VPWR VPWR _5659_/D sky130_fd_sc_hd__and2b_1
XFILLER_20_3 VPWR VGND VPWR VGND sky130_ef_sc_hd__decap_12
XFILLER_66_244 VGND VGND VPWR VPWR sky130_fd_sc_hd__decap_8
XFILLER_39_447 VGND VGND VPWR VPWR sky130_fd_sc_hd__fill_1
XANTENNA_clkbuf_leaf_6_clk_A clkbuf_leaf_9_clk/A VGND VGND VPWR VPWR sky130_fd_sc_hd__diode_2
XFILLER_26_119 VGND VGND VPWR VPWR sky130_fd_sc_hd__fill_1
XTAP_TAPCELL_ROW_37_637 VGND VPWR sky130_fd_sc_hd__tapvpwrvgnd_1
XTAP_TAPCELL_ROW_37_648 VGND VPWR sky130_fd_sc_hd__tapvpwrvgnd_1
XANTENNA__2725__A _5489_/Q VGND VGND VPWR VPWR sky130_fd_sc_hd__diode_2
XFILLER_34_163 VPWR VGND VPWR VGND sky130_ef_sc_hd__decap_12
X_5813_ clkload4/A _5813_/D fanout278/X VGND VGND VPWR VPWR _5813_/Q sky130_fd_sc_hd__dfrtp_1
XTAP_TAPCELL_ROW_17_394 VGND VPWR sky130_fd_sc_hd__tapvpwrvgnd_1
X_2956_ _3240_/B VGND VGND VPWR VPWR _3953_/C sky130_fd_sc_hd__inv_2
X_5744_ clkload9/A _5744_/D fanout284/X VGND VGND VPWR VPWR _5744_/Q sky130_fd_sc_hd__dfrtp_1
X_2887_ _5877_/Q _2916_/B _2926_/B1 _5873_/Q VGND VGND VPWR VPWR _2889_/B sky130_fd_sc_hd__a22o_1
X_5675_ _5690_/CLK hold3/X VGND VGND VPWR VPWR _5675_/Q sky130_fd_sc_hd__dfxtp_1
X_4626_ _5467_/Q _5793_/Q _4674_/S VGND VGND VPWR VPWR _4626_/X sky130_fd_sc_hd__mux2_1
X_4557_ _5765_/Q _5189_/A2 _3541_/Y _5863_/D VGND VGND VPWR VPWR _5765_/D sky130_fd_sc_hd__a22o_1
X_4488_ _4487_/A _4487_/C _3626_/A VGND VGND VPWR VPWR _4488_/Y sky130_fd_sc_hd__a21oi_1
X_3508_ _3508_/A _3509_/B VGND VGND VPWR VPWR _3508_/X sky130_fd_sc_hd__and2_1
XANTENNA__3637__A_N _4873_/A VGND VGND VPWR VPWR sky130_fd_sc_hd__diode_2
X_3439_ hold28/X _5586_/Q _3442_/S VGND VGND VPWR VPWR _5553_/D sky130_fd_sc_hd__mux2_1
XFILLER_58_712 VGND VGND VPWR VPWR sky130_fd_sc_hd__fill_1
X_6158_ _6159_/CLK _6158_/D fanout287/X VGND VGND VPWR VPWR _6158_/Q sky130_fd_sc_hd__dfrtp_1
X_5109_ _6032_/Q _6174_/Q _5109_/S VGND VGND VPWR VPWR _6032_/D sky130_fd_sc_hd__mux2_1
X_6089_ _6093_/CLK _6089_/D fanout346/X VGND VGND VPWR VPWR _6089_/Q sky130_fd_sc_hd__dfrtp_1
XPHY_EDGE_ROW_11_Left_92 VGND VGND VPWR VPWR sky130_fd_sc_hd__decap_3
XFILLER_25_141 VGND VGND VPWR VPWR sky130_fd_sc_hd__decap_4
XFILLER_41_612 VGND VGND VPWR VPWR sky130_fd_sc_hd__decap_4
XANTENNA__5719__Q _5719_/Q VGND VGND VPWR VPWR sky130_fd_sc_hd__diode_2
XFILLER_15_53 VGND VGND VPWR VPWR sky130_fd_sc_hd__decap_3
XANTENNA__5157__S _5170_/S VGND VGND VPWR VPWR sky130_fd_sc_hd__diode_2
XFILLER_21_380 VPWR VGND VPWR VGND sky130_ef_sc_hd__decap_12
XFILLER_5_513 VGND VGND VPWR VPWR sky130_fd_sc_hd__fill_1
XANTENNA__3921__B1 _3559_/Y VGND VGND VPWR VPWR sky130_fd_sc_hd__diode_2
XANTENNA__3913__B _3913_/B VGND VGND VPWR VPWR sky130_fd_sc_hd__diode_2
XANTENNA__3405__S _3407_/S VGND VGND VPWR VPWR sky130_fd_sc_hd__diode_2
XFILLER_49_712 VGND VGND VPWR VPWR sky130_fd_sc_hd__fill_1
XANTENNA__4229__A1 _5766_/Q VGND VGND VPWR VPWR sky130_fd_sc_hd__diode_2
XANTENNA__4584__X _4584_/X VGND VGND VPWR VPWR sky130_fd_sc_hd__diode_2
XFILLER_36_417 VGND VGND VPWR VPWR sky130_fd_sc_hd__decap_3
XFILLER_17_620 VPWR VGND VPWR VGND sky130_ef_sc_hd__decap_12
XFILLER_63_247 VGND VGND VPWR VPWR sky130_fd_sc_hd__decap_3
XTAP_TAPCELL_ROW_34_607 VGND VPWR sky130_fd_sc_hd__tapvpwrvgnd_1
XTAP_TAPCELL_ROW_62_949 VGND VPWR sky130_fd_sc_hd__tapvpwrvgnd_1
XFILLER_32_645 VGND VGND VPWR VPWR sky130_fd_sc_hd__fill_2
X_2810_ _2920_/B _2925_/B _6079_/Q _2895_/A VGND VGND VPWR VPWR _2810_/X sky130_fd_sc_hd__and4bb_1
XTAP_TAPCELL_ROW_14_353 VGND VPWR sky130_fd_sc_hd__tapvpwrvgnd_1
X_3790_ _3900_/A _5851_/Q VGND VGND VPWR VPWR _3790_/X sky130_fd_sc_hd__and2_1
X_2741_ _4876_/A VGND VGND VPWR VPWR _4977_/A sky130_fd_sc_hd__inv_2
X_5460_ _5458_/X _5459_/Y _4157_/A VGND VGND VPWR VPWR _6177_/D sky130_fd_sc_hd__o21a_1
XFILLER_8_362 VGND VGND VPWR VPWR sky130_fd_sc_hd__fill_2
XFILLER_68_3 VGND VGND VPWR VPWR sky130_fd_sc_hd__decap_4
X_4411_ _5740_/Q _4357_/B _4462_/A _4410_/Y VGND VGND VPWR VPWR _5740_/D sky130_fd_sc_hd__a22o_1
X_5391_ _6167_/Q _5441_/B VGND VGND VPWR VPWR _5391_/Y sky130_fd_sc_hd__nand2_1
X_4342_ _4342_/A _4342_/B VGND VGND VPWR VPWR _5197_/B sky130_fd_sc_hd__or2_2
Xfanout308 fanout309/X VGND VGND VPWR VPWR fanout308/X sky130_fd_sc_hd__clkbuf_2
X_4273_ _5703_/Q _4273_/B VGND VGND VPWR VPWR _4273_/Y sky130_fd_sc_hd__nand2_1
Xfanout319 fanout323/X VGND VGND VPWR VPWR fanout319/X sky130_fd_sc_hd__clkbuf_4
X_3224_ _5094_/A1 _5489_/Q _3229_/S VGND VGND VPWR VPWR _5489_/D sky130_fd_sc_hd__mux2_1
X_6012_ _6092_/CLK _6012_/D fanout339/X VGND VGND VPWR VPWR _6012_/Q sky130_fd_sc_hd__dfrtp_1
.ends
